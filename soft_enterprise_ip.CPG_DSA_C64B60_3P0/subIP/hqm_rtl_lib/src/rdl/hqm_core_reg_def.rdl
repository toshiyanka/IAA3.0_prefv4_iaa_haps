reg hqm_core_ctrl_r {
     name = "HQM core control register";
     desc = "HQM core control register";
     
     default hw = rw;
     default sw = rw;
     regwidth = 32;

     field { AccessType = "RW"; name = "Ctrl Field0"; desc = "control field 0"; } ctrl_field0[7:0]         = 8'h00;
     field { AccessType = "RW"; name = "Ctrl Field1"; desc = "control field 1"; } ctrl_field1[15:8]        = 8'h11;
     field { AccessType = "RW"; name = "Ctrl Field2"; desc = "control field 2"; } ctrl_field2[23:16]       = 8'h22;
     field { AccessType = "RW"; name = "Ctrl Field3"; desc = "control field 3"; } ctrl_field3[31:24]       = 8'h33;
};

reg hqm_core_status_r {
     name = "HQM core status register";
     desc = "HQM core status register";
     
     default hw = r;
     default sw = r;
     regwidth = 32;

     field { AccessType = "RO/V"; name = "Status Field0"; desc = "control field 0"; } status_field0[7:0] = 8'h0;
     field { AccessType = "RO/V"; name = "Status Field1"; desc = "control field 1"; } status_field1[15:8] = 8'h0;
     field { AccessType = "RO/V"; name = "Status Field2"; desc = "control field 2"; } status_field2[23:16] = 8'h0;
     field { AccessType = "RO/V"; name = "Status Field3"; desc = "control field 3"; } status_field3[31:24] = 8'h0;
};

reg hqm_core_int_mem_r {
     name = "HQM core internal memory";
     desc = "HQM core internal memory";
     
     default hw = rw;
     default sw = rw;
     regwidth = 32;

     field { AccessType = "RW"; name = "Int Mem Field0"; desc = "control field 0"; } int_mem_field0[7:0]         = 8'h10;
     field { AccessType = "RW"; name = "Int Mem Field1"; desc = "control field 1"; } int_mem_field1[15:8]        = 8'h32;
     field { AccessType = "RW"; name = "Int Mem Field2"; desc = "control field 2"; } int_mem_field2[23:16]       = 8'h54;
     field { AccessType = "RW"; name = "Int Mem Field3"; desc = "control field 3"; } int_mem_field3[31:24]       = 8'h76;
};

reg hqm_core_ext_mem_r {
     name = "HQM core external memory";
     desc = "HQM core external memory";
     
     default hw = rw;
     default sw = r;
     regwidth = 32;
     HandCoded=true;

     field { AccessType = "RW"; name = "Ext Mem Field0"; desc = "control field 0"; } ext_mem_field0[7:0]         = 8'h10;
     field { AccessType = "RW"; name = "Ext Mem Field1"; desc = "control field 1"; } ext_mem_field1[15:8]        = 8'h32;
     field { AccessType = "RW"; name = "Ext Mem Field2"; desc = "control field 2"; } ext_mem_field2[23:16]       = 8'h54;
     field { AccessType = "RW"; name = "Ext Mem Field3"; desc = "control field 3"; } ext_mem_field3[31:24]       = 8'h76;
};

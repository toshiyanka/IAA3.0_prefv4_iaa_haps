//SOCFuseGen
//SOCFuseGen Automatically generated by AcesXLSX2SystemRDL.pl
//SOCFuseGen Version: 2.1.15
//SOCFuseGen User: coyne
//SOCFuseGen Timestamp: Wed Apr 13 10:01:03 2016
//SOCFuseGen

`include "fuse_udp.rdl"
`include "hqm_fuses.rdl"

  addrmap hqm_top {
    field default_field {
      //**** DO NOT MODIFY CODE BELOW ****
      <% foreach $prop (keys %FieldProps) { %>
        <%=$prop%> = <%=$FieldProps{$prop}%>;
      <% } %>
      //**** DO NOT MODIFY CODE ABOVE ****
  
      // Description of this register field.
      desc = "This is the default field any register that instantiates this field will inherit all of the properties that are assigned in this field.";
    };

    TableType = "Fuse SOC Template 2.1.13";
    IntelHVMExtraHDArrays = 0;
    IntelIFPExtraHDArrays = 0;
    OEMIFPExtraHDArrays = 0;
    IntelKAR = 32'hA2832FB5;
    OEMKAR = 32'hD4FE8063;
    MaxHDArrays = 8;
    IntelHVMMaxHDArrays = 8;
    IntelIFPMaxHDArrays = 0;
    OEMIFPMaxHDArrays = 0;
    FusePullersSAI = 38;
    FuseControllerSAI = 36;
    HDProgramCount = 6;
    HDSenseCount = 9;
    BAR0SAIControlPolicy = 64'h0000000001010000;
    BAR3SAIWRPolicy = 64'h0000000001010000;
    BAR3SAIRDPolicy = 64'h0000000001010000;
    BAR4SAIWRPolicy = 64'h0000000001010000;
    BAR4SAIRDPolicy = 64'h0000000001010000;
    BAR5SAIWRPolicy = 64'h0000000001010000;
    BAR5SAIRDPolicy = 64'h0000000001010000;
    BAR6SAIWRPolicy = 64'h0000000001010000;
    BAR6SAIRDPolicy = 64'h0000000001010000;
    BAR7SAIWRPolicy = 64'h0000000001010000;
    BAR7SAIRDPolicy = 64'h0000000001010000;
    IntelHVMLockoutSAIRDPolicy = 64'h0000000001010000;
    IntelHVMLockoutSAIWRPolicy = 64'h0000000001010000;
    IntelHVMHeapSAIRDPolicy = 64'h0000000001010000;
    IntelHVMHeapSAIWRPolicy = 64'h0000000001010000;
    IntelHVMVFSAIRDPolicy = 64'h0000000001010000;
    IntelHVMVFSAIWRPolicy = 64'h0000000001010000;
    IntelHVMDFSAIRDPolicy = 64'h0000000001010000;
    IntelHVMDFSAIWRPolicy = 64'h0000000001010000;
    IntelIFPLockoutSAIRDPolicy = 64'h0000000001010000;
    IntelIFPLockoutSAIWRPolicy = 64'h0000000001010000;
    IntelIFPHeapSAIRDPolicy = 64'h0000000001010000;
    IntelIFPHeapSAIWRPolicy = 64'h0000000001010000;
    IntelIFPDFSAIRDPolicy = 64'h0000000001010000;
    IntelIFPDFSAIWRPolicy = 64'h0000000001010000;
    OEMIFPLockoutSAIRDPolicy = 64'h0000000001010000;
    OEMIFPLockoutSAIWRPolicy = 64'h0000000001010000;
    OEMIFPHeapSAIRDPolicy = 64'h0000000001010000;
    OEMIFPHeapSAIWRPolicy = 64'h0000000001010000;
    OEMIFPDFSAIRDPolicy = 64'h0000000001010000;
    OEMIFPDFSAIWRPolicy = 64'h0000000001010000;
    FuseMemLimit = "";
    StrapMemLimit = "";
    SoC_dependencies = "";

    hqm hqm;
    hqm->IOSFSBEP = 1;
    hqm->IOSFSBPortID = 8'h21;
    hqm->RTLSignalPathPrefix = "hqm_tb.hqm";
  };


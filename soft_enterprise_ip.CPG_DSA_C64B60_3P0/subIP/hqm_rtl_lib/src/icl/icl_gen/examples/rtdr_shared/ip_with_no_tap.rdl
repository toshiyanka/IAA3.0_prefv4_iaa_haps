// IP TAP RDL example:
//    Two TDR registers, no TAP controller

addrmap ip_with_no_tap_def {

   name    = "IP";
   desc    = "IP description";

   // Indication of IP without TAP controller
   TapType = "reg_only";

   // Register Definitions

   reg regA_def {
      name = "regA register";
      desc = "regA description";
      TapShiftRegLength  = 6;
      TapTotalNumRegBits = 6;
      regwidth = 8;
      TapRegResetType = "PWRGOOD";
      TapOpcodeSecurityLevel = "SECURE_RED";
   
      // IMPORTANT: Fields are instantiated in the order
      // from TDO (lsb) to TDI (msb) 
      field {
         name = "f1 field";
         desc = "f1 description";
         AccessType = "RW";
      } f1 [4] = 4'h0; // [3:0]
   
      field {
         name = "f2 field";
         desc = "f2 description";
         AccessType = "RW/V";
      } f2 [1] = 1'h0; // [4:4]
   
      field {
         name = "f3 field";
         desc = "f3 description";
         AccessType = "WO";
      } f3 [1] = 1'h0; // [5:5]
   
   }; // end of reg regA_def

   reg regB_def {
      name = "regB register";
      desc = "regB description";
      TapShiftRegLength  = 12;
      TapTotalNumRegBits = 12;
      regwidth = 16;
      TapOpcodeSecurityLevel = "SECURE_GREEN";
   
      // IMPORTANT: Fields are instantiated in the order
      // from TDO (lsb) to TDI (msb) 
      field {
         name = "f1 field";
         desc = "f1 description";
         AccessType = "RO";
      } f1 [4] = 4'h5; // [3:0]
   
      field {
         name = "f2 field";
         desc = "f2 description";
         AccessType = "RO/V";
      } f2 [8] = 8'h0; // [11:4]
   
   }; // end of reg regB_def


   // Register/Chain Instantiations

   regA_def regA;
   regB_def regB;


}; // end of addrmap ip_with_no_tap_def


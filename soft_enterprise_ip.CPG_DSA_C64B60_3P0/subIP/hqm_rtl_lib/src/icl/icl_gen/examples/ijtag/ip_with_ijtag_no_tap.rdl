// IP TAP RDL example:
//    Single IJTAG chain, no TAP controller

addrmap ip_with_ijtag_no_tap_def {

   name    = "IP";
   desc    = "IP description";

   // Indication of IP without TAP controller
   TapType = "reg_only";

   // Register Definitions

   reg regA_def {
      name = "regA register";
      desc = "regA description";
      TapShiftRegLength  = 6;
      TapTotalNumRegBits = 6;
      regwidth = 8;
      TapRegResetType = "PWRGOOD";
      TapOpcodeSecurityLevel = "SECURE_RED";
   
      // IMPORTANT: Fields are instantiated in the order
      // from TDO (lsb) to TDI (msb) 
      field {
         name = "f1 field";
         desc = "f1 description";
         AccessType = "RW";
      } f1 [4] = 4'h0; // [3:0]
   
      field {
         name = "f2 field";
         desc = "f2 description";
         AccessType = "RW/V";
      } f2 [1] = 1'h0; // [4:4]
   
      field {
         name = "f3 field";
         desc = "f3 description";
         AccessType = "WO";
      } f3 [1] = 1'h0; // [5:5]
   
   }; // end of reg regA_def

   reg regB_def {
      name = "regB register";
      desc = "regB description";
      TapShiftRegLength  = 12;
      TapTotalNumRegBits = 12;
      regwidth = 16;
      TapOpcodeSecurityLevel = "SECURE_GREEN";
   
      // IMPORTANT: Fields are instantiated in the order
      // from TDO (lsb) to TDI (msb) 
      field {
         name = "f1 field";
         desc = "f1 description";
         AccessType = "RO";
      } f1 [4] = 4'h5; // [3:0]
   
      field {
         name = "f2 field";
         desc = "f2 description";
         AccessType = "RO/V";
      } f2 [8] = 8'h0; // [11:4]
   
   }; // end of reg regB_def

   reg sib_reg_def {
      name = "SIB";
      desc = "Segment Insertion BIT for IJTAG";
      TapTotalNumRegBits = 1;
      TapShiftRegLength  = 1;
      regwidth = 8;
      TapRegType = "SIB";
      TapRegResetType = "PWRGOOD, TRST, TLR";
   
      field {
         name = "SIB";
         desc = "Segment Insertion Bit";
         AccessType = "RW";
      } sib [1] = 1'h0; // [0:0]
   }; // end of reg sib_reg_def

   //---------------------------
   // IJTAG chain definition
   // IMPORTANT: TDR's and SIB's must be instantiated in the following order: from TDO/lsb (top) to TDI/msb (bottom)
   // Flat chain layout:
   //    TDI -> regB -> sibB -> regA -> sibA -> sib_top -> TDO
   //

   regfile ijtag_chain_def {
      name = "IJTAG chain";
      desc = "IJTAG chain description";
      TapOpcodeSecurityLevel = "SECURE_RED";
      TapRegType = "IJTAG";
   
      //---------------------------
      sib_reg_def sib_top;
   
      //---------------------------
      sib_reg_def sibA;
         sibA -> TapSibRef = "sib_top";
   
      //---------------------------
      regA_def regA;
         regA -> TapSibRef = "sibA";
   
      //---------------------------
      sib_reg_def sibB;
         sibB -> TapSibRef = "sib_top";
   
      //---------------------------
      regB_def regB;
         regB -> TapSibRef = "sibB";
   
   }; // end of regfile ijtag_chain_def

   // Register/Chain Instantiations

   ijtag_chain_def chain_1;

}; // end of addrmap ip_with_ijtag_no_tap_def


// This file is generated by gen_rtdr_coll.perl
// For changes please edit RTDR_data.csv and not this output file

// IP with separate interfaces for TDR registers (no TAP controller)

addrmap hqm {

  name    = "HQM";
  desc    = "Hardware Queue Manager";

  // Indication of IP without TAP controller
  TapType = "reg_only";

  // Register Definitions

   reg iosfsb_ism_def {
     name = "iosfsb_ism";
     desc = "iosfsb_ism register";
     TapShiftRegLength  = 32;
     TapTotalNumRegBits = 32;
     regwidth = 32;
     TapRegResetType = "PWRGOOD_iosfsb_ism";
     TapOpcodeSecurityLevel = "RED";

     // IMPORTANT: Fields are instantiated in the order
     // from TDO (lsb) to TDI (msb)

     field {
       name = "SIDE_CLKG_OVRD";
       desc = "cdc_side_jta_clkgate_ovrd";
       AccessType = "RW";
     } SIDE_CLKG_OVRD [1] = 1'b0; // [0:0]

     field {
       name = "PRIM_CLKG_OVRD";
       desc = "cdc_prim_jta_clkgate_ovrd.  Also hqm_master/cdc_hqm_jta_clkgate_ovrd";
       AccessType = "RW";
     } PRIM_CLKG_OVRD [1] = 1'b0; // [1:1]

     field {
       name = "PRIM_FRC_CLKRQ";
       desc = "cdc_prim_jta_force_clkreq.  Also prim_jta_force_clkreq and hqm_master/cdc_hqm_jta_force_clkreq";
       AccessType = "RW";
     } PRIM_FRC_CLKRQ [1] = 1'b0; // [2:2]

     field {
       name = "PRIM_FRC_CREDRQ";
       desc = "prim_jta_force_creditreq";
       AccessType = "RW";
     } PRIM_FRC_CREDRQ [1] = 1'b0; // [3:3]

     field {
       name = "PRIM_FRC_NIDLE";
       desc = "prim_jta_force_notidle";
       AccessType = "RW";
     } PRIM_FRC_NIDLE [1] = 1'b0; // [4:4]

     field {
       name = "PRIM_FRC_IDLE";
       desc = "prim_jta_force_idle";
       AccessType = "RW";
     } PRIM_FRC_IDLE [1] = 1'b0; // [5:5]

     field {
       name = "RESERVED_II0";
       desc = "Reserved for future use";
       AccessType = "RW";
     } RESERVED_II0 [5] = 5'd0; // [10:6]

     field {
       name = "GPSB_CLKG_OVRD";
       desc = "gpsb_jta_clkgate_ovrd";
       AccessType = "RW";
     } GPSB_CLKG_OVRD [1] = 1'b0; // [11:11]

     field {
       name = "SIDE_FRC_CLKRQ";
       desc = "cdc_side_jta_force_clkreq.  Also gpsb_jta_force_clkreq";
       AccessType = "RW";
     } SIDE_FRC_CLKRQ [1] = 1'b0; // [12:12]

     field {
       name = "SIDE_FRC_CREDRQ";
       desc = "gpsb_jta_force_creditreq";
       AccessType = "RW";
     } SIDE_FRC_CREDRQ [1] = 1'b0; // [13:13]

     field {
       name = "SIDE_FRC_NIDLE";
       desc = "gpsb_jta_force_notidle";
       AccessType = "RW";
     } SIDE_FRC_NIDLE [1] = 1'b0; // [14:14]

     field {
       name = "SIDE_FRC_IDLE";
       desc = "gpsb_jta_force_idle";
       AccessType = "RW";
     } SIDE_FRC_IDLE [1] = 1'b0; // [15:15]

     field {
       name = "RESERVED_II1";
       desc = "Reserved for future use";
       AccessType = "RW";
     } RESERVED_II1 [16] = 16'd0; // [31:16]
   }; // end of reg iosfsb_ism_def

   reg tapconfig_def {
     name = "tapconfig";
     desc = "tapconfig register";
     TapShiftRegLength  = 32;
     TapTotalNumRegBits = 32;
     regwidth = 32;
     TapRegResetType = "PWRGOOD_tapconfig";
     TapOpcodeSecurityLevel = "RED";

     // IMPORTANT: Fields are instantiated in the order
     // from TDO (lsb) to TDI (msb)

     field {
       name = "RESERVED_TC0";
       desc = "Reserved for future use";
       AccessType = "RW";
     } RESERVED_TC0 [1] = 1'b0; // [0:0]

     field {
       name = "PGCB_BYP";
       desc = "fdfx_pgcb_bypass";
       AccessType = "RW";
     } PGCB_BYP [1] = 1'b0; // [1:1]

     field {
       name = "PGCB_OVR";
       desc = "fdfx_pgcb_ovr";
       AccessType = "RW";
     } PGCB_OVR [1] = 1'b0; // [2:2]

     field {
       name = "FET_ON";
       desc = "fscan_fet_on";
       AccessType = "RW";
     } FET_ON [1] = 1'b0; // [3:3]

     field {
       name = "FET_EN_SEL";
       desc = "fscan_fet_en_sel";
       AccessType = "RW";
     } FET_EN_SEL [1] = 1'b0; // [4:4]

     field {
       name = "VIEWPIN0_SEL";
       desc = "Select for viewpin[0].  0:hqm_cdc_clkreq ; 1:pmsm active ; 2:pgcb force reset ; 3:pgcb_isol_en_b ; 4:pgcb_hqm_pwrgate_active ; 5:fet_en_ack_b to hqm_pm_unit ; 6:fet_en_b indication from pgcbunit";
       AccessType = "RW";
     } VIEWPIN0_SEL [3] = 3'd0; // [7:5]

     field {
       name = "VIEWPIN1_SEL";
       desc = "Select for viewpin[1], same encoding as sel0";
       AccessType = "RW";
     } VIEWPIN1_SEL [3] = 3'd0; // [10:8]

     field {
       name = "FORCE_POWER_ON";
       desc = "Forces PM state machine to the ON/RUN state";
       AccessType = "RW";
     } FORCE_POWER_ON [1] = 1'b0; // [11:11]

     field {
       name = "RESERVED_TC1";
       desc = "Reserved for future use";
       AccessType = "RW";
     } RESERVED_TC1 [20] = 20'd0; // [31:12]
   }; // end of reg tapconfig_def

   reg taptrigger_def {
     name = "taptrigger";
     desc = "taptrigger register";
     TapShiftRegLength  = 32;
     TapTotalNumRegBits = 32;
     regwidth = 32;
     TapRegResetType = "PWRGOOD_taptrigger";
     TapOpcodeSecurityLevel = "RED";

     // IMPORTANT: Fields are instantiated in the order
     // from TDO (lsb) to TDI (msb)

     field {
       name = "TRIG_IOSF";
       desc = "fscan_trigger_mask for IOSF";
       AccessType = "RW";
     } TRIG_IOSF [10] = 10'd0; // [9:0]

     field {
       name = "TRIG_PM_0";
       desc = "fscan_trigger_mask for PM 0";
       AccessType = "RW";
     } TRIG_PM_0 [10] = 10'd0; // [19:10]

     field {
       name = "TRIG_PM_1";
       desc = "fscan_trigger_mask for PM 1";
       AccessType = "RW";
     } TRIG_PM_1 [10] = 10'd0; // [29:20]

     field {
       name = "TRIG_VALID";
       desc = "fscan_trigger_valid: Rising edge loads trigger mask values into mask register";
       AccessType = "RW";
     } TRIG_VALID [1] = 1'b0; // [30:30]

     field {
       name = "RESERVED_TT0";
       desc = "Reserved for future use";
       AccessType = "RW";
     } RESERVED_TT0 [1] = 1'b0; // [31:31]
   }; // end of reg taptrigger_def


   // Register/Chain Instantiations

   iosfsb_ism_def iosfsb_ism;
   tapconfig_def tapconfig;
   taptrigger_def taptrigger;


}; // end of addrmap hqm

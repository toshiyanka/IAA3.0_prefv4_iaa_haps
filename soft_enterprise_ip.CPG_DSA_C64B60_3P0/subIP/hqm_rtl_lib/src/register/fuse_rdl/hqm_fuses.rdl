//SOCFuseGen
//SOCFuseGen Automatically generated by AcesXML2SystemRDL.pl
//SOCFuseGen Version: d22ww30.5
//SOCFuseGen

`include "fuse_udp.rdl"

  addrmap hqm {
    field default_field {
      //**** DO NOT MODIFY CODE BELOW ****
      <% foreach $prop (keys %FieldProps) { %>
        <%=$prop%> = <%=$FieldProps{$prop}%>;
      <% } %>
      //**** DO NOT MODIFY CODE ABOVE ****
  
      // Description of this register field.
      desc = "This is the default field any register that instantiates this field will inherit all of the properties that are assigned in this field.";
    };

    TableType = "Fuse IP Template 2.1.13";
    CmplFmt = 1;
    LegacyConverted = false;
    FuseMemLimit = "";
    FuseMemLimitIntelHVM = "";
    FuseMemLimitIntelIFP = "";
    FuseMemLimitOEMIFP = "";
    StrapMemLimit = "";
    PullTrigger = "Group0=side_rst_b";
    IP_dependencies = "";

    reg hqm {
      regwidth = 32;  // make blueprint happy 

      default_field proc_disable = 1'h0;
      proc_disable->StartBit = 0;
      proc_disable->VFOverrideDisable = false;
      proc_disable->JTagWR = true;
      proc_disable->desc = "HQM Proc Disabled";
      proc_disable->SubClass = "Functional";
      proc_disable->name = "proc_disable";
      proc_disable->JTagRD = true;
      proc_disable->Group = "DirectFuse";
      proc_disable->Class = "Feature";
      proc_disable->BlkOnDbg = false;
      proc_disable->LLDD = false;
      proc_disable->SharedTagPivot = "";
      proc_disable->EncodingValueType = "KeyValuePairs";
      proc_disable->EncodingValues = "Enabled,1'h0; Disabled,1'h1";
      proc_disable->SharedTag = "";
      proc_disable->LockoutValidIDTag = "";
      proc_disable->CSRRD = true;
      proc_disable->RTLSignalPath = "hqm_sip_aon_wrap.i_hqm_sif.i_hqm_sif_core.i_hqm_iosfsb_core.i_hqm_msg_wrapper.fp_fuses[0]";
      proc_disable->Category = "IntelHVM";
      proc_disable->Consumer = "IPHardware";
      proc_disable->CSRWR = true;
      proc_disable->Units = "";
      proc_disable->GroupNumber = 0;
      proc_disable->IPResetType = "side_rst_b";
      proc_disable->ArrayType = "HighDensity";
      proc_disable->IPOwner = "stepollo";
      proc_disable->Shared = false;
      proc_disable->RcvrAddr = 16'h0000;
      proc_disable->PullOnce = false;
      proc_disable->FUSE_WIDTH = 1;
      proc_disable->RD4Err = true;
      proc_disable->FuseDefaultValue = 1'h0;
      proc_disable->ExternalCustomerVisible = false;

      default_field force_on = 1'h0;
      force_on->StartBit = 1;
      force_on->VFOverrideDisable = false;
      force_on->JTagWR = true;
      force_on->desc = "HQM Force On";
      force_on->SubClass = "ChickenBit";
      force_on->name = "force_on";
      force_on->JTagRD = true;
      force_on->Group = "DirectFuse";
      force_on->Class = "Feature";
      force_on->BlkOnDbg = false;
      force_on->LLDD = false;
      force_on->SharedTagPivot = "";
      force_on->EncodingValueType = "KeyValuePairs";
      force_on->EncodingValues = "NoForce,1'h0; ForceOn,1'h1";
      force_on->SharedTag = "";
      force_on->LockoutValidIDTag = "";
      force_on->CSRRD = true;
      force_on->RTLSignalPath = "hqm_sip_aon_wrap.i_hqm_sif.i_hqm_sif_core.i_hqm_sifsb_core.i_hqm_msg_wrapper.fp_fuses[1]";
      force_on->Category = "IntelHVM";
      force_on->Consumer = "IPHardware";
      force_on->CSRWR = true;
      force_on->Units = "";
      force_on->GroupNumber = 0;
      force_on->IPResetType = "side_rst_b";
      force_on->ArrayType = "HighDensity";
      force_on->IPOwner = "stepollo";
      force_on->Shared = false;
      force_on->RcvrAddr = 16'h0000;
      force_on->PullOnce = false;
      force_on->FUSE_WIDTH = 1;
      force_on->RD4Err = true;
      force_on->FuseDefaultValue = 1'h0;
      force_on->ExternalCustomerVisible = false;

      default_field hqm_spare_reserved = 1'h0;
      hqm_spare_reserved->StartBit = 2;
      hqm_spare_reserved->VFOverrideDisable = false;
      hqm_spare_reserved->JTagWR = true;
      hqm_spare_reserved->desc = "Reserved HQM Spare";
      hqm_spare_reserved->SubClass = "Reserved";
      hqm_spare_reserved->name = "hqm_spare_reserved";
      hqm_spare_reserved->JTagRD = true;
      hqm_spare_reserved->Group = "DirectFuse";
      hqm_spare_reserved->Class = "Spare";
      hqm_spare_reserved->BlkOnDbg = false;
      hqm_spare_reserved->LLDD = false;
      hqm_spare_reserved->SharedTagPivot = "";
      hqm_spare_reserved->EncodingValueType = "KeyValuePairs";
      hqm_spare_reserved->EncodingValues = "Spare0,6'h00;Spare1,6'h01;Spare2,6'h02;Spare3,6'h03;Spare4,6'h04;Spare5,6'h05;Spare6,6'h06;Spare7,6'h07;Spare8,6'h08;Spare9,6'h09;Spare10,6'h0a;Spare11,6'h0b;Spare12,6'h0c;Spare13,6'h0d;Spare14,6'h0e;Spare15,6'h0f;Spare16,6'h10;Spare17,6'h11;Spare18,6'h12;Spare19,6'h13;Spare20,6'h14;Spare21,6'h15;Spare22,6'h16;Spare23,6'h17;Spare24,6'h18;Spare25,6'h19;Spare26,6'h1a;Spare27,6'h1b;Spare28,6'h1c;Spare29,6'h1d;Spare30,6'h1e;Spare31,6'h1f;Spare32,6'h20;Spare33,6'h21;Spare34,6'h22;Spare35,6'h23;Spare36,6'h24;Spare37,6'h25;Spare38,6'h26;Spare39,6'h27;Spare40,6'h28;Spare41,6'h29;Spare42,6'h2a;Spare43,6'h2b;Spare44,6'h2c;Spare45,6'h2d;Spare46,6'h2e;Spare47,6'h2f;Spare48,6'h30;Spare49,6'h31;Spare50,6'h32;Spare51,6'h33;Spare52,6'h34;Spare53,6'h35;Spare54,6'h36;Spare55,6'h37;Spare56,6'h38;Spare57,6'h39;Spare58,6'h3a;Spare59,6'h3b;Spare60,6'h3c;Spare61,6'h3d;Spare62,6'h3e;Spare63,6'h3f";
      hqm_spare_reserved->SharedTag = "";
      hqm_spare_reserved->LockoutValidIDTag = "";
      hqm_spare_reserved->CSRRD = true;
      hqm_spare_reserved->RTLSignalPath = "hqm_sip_aon_wrap.i_hqm_sif.i_hqm_sif_core.i_hqm_iosfsb_core.i_hqm_msg_wrapper.fp_fuses[7:2]";
      hqm_spare_reserved->Category = "IntelHVM";
      hqm_spare_reserved->Consumer = "IPHardware";
      hqm_spare_reserved->CSRWR = true;
      hqm_spare_reserved->Units = "";
      hqm_spare_reserved->GroupNumber = 0;
      hqm_spare_reserved->IPResetType = "side_rst_b";
      hqm_spare_reserved->ArrayType = "HighDensity";
      hqm_spare_reserved->IPOwner = "stepollo";
      hqm_spare_reserved->Shared = false;
      hqm_spare_reserved->RcvrAddr = 16'h0000;
      hqm_spare_reserved->PullOnce = false;
      hqm_spare_reserved->FUSE_WIDTH = 6;
      hqm_spare_reserved->RD4Err = true;
      hqm_spare_reserved->FuseDefaultValue = 6'h00;
      hqm_spare_reserved->ExternalCustomerVisible = false;

      default_field revision_id = 1'h0;
      revision_id->StartBit = 0;
      revision_id->VFOverrideDisable = false;
      revision_id->JTagWR = true;
      revision_id->desc = "Revision ID";
      revision_id->SubClass = "Functional";
      revision_id->name = "revision_id";
      revision_id->JTagRD = true;
      revision_id->Group = "DirectFuse";
      revision_id->Class = "Feature";
      revision_id->BlkOnDbg = false;
      revision_id->LLDD = false;
      revision_id->SharedTagPivot = "";
      revision_id->EncodingValueType = "KeyValuePairs";
      revision_id->EncodingValues = "Revision0,8'h00;Revision1,8'h01;Revision2,8'h02;Revision3,8'h03;Revision4,8'h04;Revision5,8'h05;Revision6,8'h06;Revision7,8'h07;Revision8,8'h08;Revision9,8'h09;Revision10,8'h0a;Revision11,8'h0b;Revision12,8'h0c;Revision13,8'h0d;Revision14,8'h0e;Revision15,8'h0f;Revision16,8'h10;Revision17,8'h11;Revision18,8'h12;Revision19,8'h13;Revision20,8'h14;Revision21,8'h15;Revision22,8'h16;Revision23,8'h17;Revision24,8'h18;Revision25,8'h19;Revision26,8'h1a;Revision27,8'h1b;Revision28,8'h1c;Revision29,8'h1d;Revision30,8'h1e;Revision31,8'h1f;Revision32,8'h20;Revision33,8'h21;Revision34,8'h22;Revision35,8'h23;Revision36,8'h24;Revision37,8'h25;Revision38,8'h26;Revision39,8'h27;Revision40,8'h28;Revision41,8'h29;Revision42,8'h2a;Revision43,8'h2b;Revision44,8'h2c;Revision45,8'h2d;Revision46,8'h2e;Revision47,8'h2f;Revision48,8'h30;Revision49,8'h31;Revision50,8'h32;Revision51,8'h33;Revision52,8'h34;Revision53,8'h35;Revision54,8'h36;Revision55,8'h37;Revision56,8'h38;Revision57,8'h39;Revision58,8'h3a;Revision59,8'h3b;Revision60,8'h3c;Revision61,8'h3d;Revision62,8'h3e;Revision63,8'h3f;Revision64,8'h40;Revision65,8'h41;Revision66,8'h42;Revision67,8'h43;Revision68,8'h44;Revision69,8'h45;Revision70,8'h46;Revision71,8'h47;Revision72,8'h48;Revision73,8'h49;Revision74,8'h4a;Revision75,8'h4b;Revision76,8'h4c;Revision77,8'h4d;Revision78,8'h4e;Revision79,8'h4f;Revision80,8'h50;Revision81,8'h51;Revision82,8'h52;Revision83,8'h53;Revision84,8'h54;Revision85,8'h55;Revision86,8'h56;Revision87,8'h57;Revision88,8'h58;Revision89,8'h59;Revision90,8'h5a;Revision91,8'h5b;Revision92,8'h5c;Revision93,8'h5d;Revision94,8'h5e;Revision95,8'h5f;Revision96,8'h60;Revision97,8'h61;Revision98,8'h62;Revision99,8'h63;Revision100,8'h64;Revision101,8'h65;Revision102,8'h66;Revision103,8'h67;Revision104,8'h68;Revision105,8'h69;Revision106,8'h6a;Revision107,8'h6b;Revision108,8'h6c;Revision109,8'h6d;Revision110,8'h6e;Revision111,8'h6f;Revision112,8'h70;Revision113,8'h71;Revision114,8'h72;Revision115,8'h73;Revision116,8'h74;Revision117,8'h75;Revision118,8'h76;Revision119,8'h77;Revision120,8'h78;Revision121,8'h79;Revision122,8'h7a;Revision123,8'h7b;Revision124,8'h7c;Revision125,8'h7d;Revision126,8'h7e;Revision127,8'h7f;Revision128,8'h80;Revision129,8'h81;Revision130,8'h82;Revision131,8'h83;Revision132,8'h84;Revision133,8'h85;Revision134,8'h86;Revision135,8'h87;Revision136,8'h88;Revision137,8'h89;Revision138,8'h8a;Revision139,8'h8b;Revision140,8'h8c;Revision141,8'h8d;Revision142,8'h8e;Revision143,8'h8f;Revision144,8'h90;Revision145,8'h91;Revision146,8'h92;Revision147,8'h93;Revision148,8'h94;Revision149,8'h95;Revision150,8'h96;Revision151,8'h97;Revision152,8'h98;Revision153,8'h99;Revision154,8'h9a;Revision155,8'h9b;Revision156,8'h9c;Revision157,8'h9d;Revision158,8'h9e;Revision159,8'h9f;Revision160,8'ha0;Revision161,8'ha1;Revision162,8'ha2;Revision163,8'ha3;Revision164,8'ha4;Revision165,8'ha5;Revision166,8'ha6;Revision167,8'ha7;Revision168,8'ha8;Revision169,8'ha9;Revision170,8'haa;Revision171,8'hab;Revision172,8'hac;Revision173,8'had;Revision174,8'hae;Revision175,8'haf;Revision176,8'hb0;Revision177,8'hb1;Revision178,8'hb2;Revision179,8'hb3;Revision180,8'hb4;Revision181,8'hb5;Revision182,8'hb6;Revision183,8'hb7;Revision184,8'hb8;Revision185,8'hb9;Revision186,8'hba;Revision187,8'hbb;Revision188,8'hbc;Revision189,8'hbd;Revision190,8'hbe;Revision191,8'hbf;Revision192,8'hc0;Revision193,8'hc1;Revision194,8'hc2;Revision195,8'hc3;Revision196,8'hc4;Revision197,8'hc5;Revision198,8'hc6;Revision199,8'hc7;Revision200,8'hc8;Revision201,8'hc9;Revision202,8'hca;Revision203,8'hcb;Revision204,8'hcc;Revision205,8'hcd;Revision206,8'hce;Revision207,8'hcf;Revision208,8'hd0;Revision209,8'hd1;Revision210,8'hd2;Revision211,8'hd3;Revision212,8'hd4;Revision213,8'hd5;Revision214,8'hd6;Revision215,8'hd7;Revision216,8'hd8;Revision217,8'hd9;Revision218,8'hda;Revision219,8'hdb;Revision220,8'hdc;Revision221,8'hdd;Revision222,8'hde;Revision223,8'hdf;Revision224,8'he0;Revision225,8'he1;Revision226,8'he2;Revision227,8'he3;Revision228,8'he4;Revision229,8'he5;Revision230,8'he6;Revision231,8'he7;Revision232,8'he8;Revision233,8'he9;Revision234,8'hea;Revision235,8'heb;Revision236,8'hec;Revision237,8'hed;Revision238,8'hee;Revision239,8'hef;Revision240,8'hf0;Revision241,8'hf1;Revision242,8'hf2;Revision243,8'hf3;Revision244,8'hf4;Revision245,8'hf5;Revision246,8'hf6;Revision247,8'hf7;Revision248,8'hf8;Revision249,8'hf9;Revision250,8'hfa;Revision251,8'hfb;Revision252,8'hfc;Revision253,8'hfd;Revision254,8'hfe;Revision255,8'hff";
      revision_id->SharedTag = "";
      revision_id->LockoutValidIDTag = "";
      revision_id->CSRRD = true;
      revision_id->RTLSignalPath = "hqm_sip_aon_wrap.i_hqm_sif.i_hqm_sif_core.i_hqm_iosfsb_core.i_hqm_msg_wrapper.fp_fuses[15:8]";
      revision_id->Category = "IntelHVM";
      revision_id->Consumer = "IPHardware";
      revision_id->CSRWR = true;
      revision_id->Units = "";
      revision_id->GroupNumber = 0;
      revision_id->IPResetType = "side_rst_b";
      revision_id->ArrayType = "HighDensity";
      revision_id->IPOwner = "stepollo";
      revision_id->Shared = true;
      revision_id->RcvrAddr = 16'h0001;
      revision_id->PullOnce = false;
      revision_id->FUSE_WIDTH = 8;
      revision_id->RD4Err = true;
      revision_id->FuseDefaultValue = 8'h00;
      revision_id->ExternalCustomerVisible = false;
    };

    hqm hqm;

    reg HQM_Spare {
      regwidth = 128;  // make blueprint happy 

      ObjectType = "FEATURE";
      name = "HQM_Spare";
      FeatureDescription = "Spare bits";
      ResetValue = "HWResetConf";
      IsMarketingFeature = false;

      default_field HWResetConf = 1'h0;
      HWResetConf->name = "HWResetConf";
      HWResetConf->ValueDescription = "Reset value";
      HWResetConf->Values = "hqm_spare_reserved,Spare0";
      HWResetConf->IsMarketingValue = false;

      default_field HQM_Spare0 = 1'h0;
      HQM_Spare0->name = "HQM_Spare0";
      HQM_Spare0->ValueDescription = "Spare0 value";
      HQM_Spare0->Values = "hqm_spare_reserved,Spare0";
      HQM_Spare0->IsMarketingValue = false;

      default_field HQM_Spare1 = 1'h0;
      HQM_Spare1->name = "HQM_Spare1";
      HQM_Spare1->ValueDescription = "Spare1 value";
      HQM_Spare1->Values = "hqm_spare_reserved,Spare1";
      HQM_Spare1->IsMarketingValue = false;

      default_field HQM_Spare2 = 1'h0;
      HQM_Spare2->name = "HQM_Spare2";
      HQM_Spare2->ValueDescription = "Spare2 value";
      HQM_Spare2->Values = "hqm_spare_reserved,Spare2";
      HQM_Spare2->IsMarketingValue = false;

      default_field HQM_Spare3 = 1'h0;
      HQM_Spare3->name = "HQM_Spare3";
      HQM_Spare3->ValueDescription = "Spare3 value";
      HQM_Spare3->Values = "hqm_spare_reserved,Spare3";
      HQM_Spare3->IsMarketingValue = false;

      default_field HQM_Spare4 = 1'h0;
      HQM_Spare4->name = "HQM_Spare4";
      HQM_Spare4->ValueDescription = "Spare4 value";
      HQM_Spare4->Values = "hqm_spare_reserved,Spare4";
      HQM_Spare4->IsMarketingValue = false;

      default_field HQM_Spare5 = 1'h0;
      HQM_Spare5->name = "HQM_Spare5";
      HQM_Spare5->ValueDescription = "Spare5 value";
      HQM_Spare5->Values = "hqm_spare_reserved,Spare5";
      HQM_Spare5->IsMarketingValue = false;

      default_field HQM_Spare6 = 1'h0;
      HQM_Spare6->name = "HQM_Spare6";
      HQM_Spare6->ValueDescription = "Spare6 value";
      HQM_Spare6->Values = "hqm_spare_reserved,Spare6";
      HQM_Spare6->IsMarketingValue = false;

      default_field HQM_Spare7 = 1'h0;
      HQM_Spare7->name = "HQM_Spare7";
      HQM_Spare7->ValueDescription = "Spare7 value";
      HQM_Spare7->Values = "hqm_spare_reserved,Spare7";
      HQM_Spare7->IsMarketingValue = false;

      default_field HQM_Spare8 = 1'h0;
      HQM_Spare8->name = "HQM_Spare8";
      HQM_Spare8->ValueDescription = "Spare8 value";
      HQM_Spare8->Values = "hqm_spare_reserved,Spare8";
      HQM_Spare8->IsMarketingValue = false;

      default_field HQM_Spare9 = 1'h0;
      HQM_Spare9->name = "HQM_Spare9";
      HQM_Spare9->ValueDescription = "Spare9 value";
      HQM_Spare9->Values = "hqm_spare_reserved,Spare9";
      HQM_Spare9->IsMarketingValue = false;

      default_field HQM_Spare10 = 1'h0;
      HQM_Spare10->name = "HQM_Spare10";
      HQM_Spare10->ValueDescription = "Spare10 value";
      HQM_Spare10->Values = "hqm_spare_reserved,Spare10";
      HQM_Spare10->IsMarketingValue = false;

      default_field HQM_Spare11 = 1'h0;
      HQM_Spare11->name = "HQM_Spare11";
      HQM_Spare11->ValueDescription = "Spare11 value";
      HQM_Spare11->Values = "hqm_spare_reserved,Spare11";
      HQM_Spare11->IsMarketingValue = false;

      default_field HQM_Spare12 = 1'h0;
      HQM_Spare12->name = "HQM_Spare12";
      HQM_Spare12->ValueDescription = "Spare12 value";
      HQM_Spare12->Values = "hqm_spare_reserved,Spare12";
      HQM_Spare12->IsMarketingValue = false;

      default_field HQM_Spare13 = 1'h0;
      HQM_Spare13->name = "HQM_Spare13";
      HQM_Spare13->ValueDescription = "Spare13 value";
      HQM_Spare13->Values = "hqm_spare_reserved,Spare13";
      HQM_Spare13->IsMarketingValue = false;

      default_field HQM_Spare14 = 1'h0;
      HQM_Spare14->name = "HQM_Spare14";
      HQM_Spare14->ValueDescription = "Spare14 value";
      HQM_Spare14->Values = "hqm_spare_reserved,Spare14";
      HQM_Spare14->IsMarketingValue = false;

      default_field HQM_Spare15 = 1'h0;
      HQM_Spare15->name = "HQM_Spare15";
      HQM_Spare15->ValueDescription = "Spare15 value";
      HQM_Spare15->Values = "hqm_spare_reserved,Spare15";
      HQM_Spare15->IsMarketingValue = false;

      default_field HQM_Spare16 = 1'h0;
      HQM_Spare16->name = "HQM_Spare16";
      HQM_Spare16->ValueDescription = "Spare16 value";
      HQM_Spare16->Values = "hqm_spare_reserved,Spare16";
      HQM_Spare16->IsMarketingValue = false;

      default_field HQM_Spare17 = 1'h0;
      HQM_Spare17->name = "HQM_Spare17";
      HQM_Spare17->ValueDescription = "Spare17 value";
      HQM_Spare17->Values = "hqm_spare_reserved,Spare17";
      HQM_Spare17->IsMarketingValue = false;

      default_field HQM_Spare18 = 1'h0;
      HQM_Spare18->name = "HQM_Spare18";
      HQM_Spare18->ValueDescription = "Spare18 value";
      HQM_Spare18->Values = "hqm_spare_reserved,Spare18";
      HQM_Spare18->IsMarketingValue = false;

      default_field HQM_Spare19 = 1'h0;
      HQM_Spare19->name = "HQM_Spare19";
      HQM_Spare19->ValueDescription = "Spare19 value";
      HQM_Spare19->Values = "hqm_spare_reserved,Spare19";
      HQM_Spare19->IsMarketingValue = false;

      default_field HQM_Spare20 = 1'h0;
      HQM_Spare20->name = "HQM_Spare20";
      HQM_Spare20->ValueDescription = "Spare20 value";
      HQM_Spare20->Values = "hqm_spare_reserved,Spare20";
      HQM_Spare20->IsMarketingValue = false;

      default_field HQM_Spare21 = 1'h0;
      HQM_Spare21->name = "HQM_Spare21";
      HQM_Spare21->ValueDescription = "Spare21 value";
      HQM_Spare21->Values = "hqm_spare_reserved,Spare21";
      HQM_Spare21->IsMarketingValue = false;

      default_field HQM_Spare22 = 1'h0;
      HQM_Spare22->name = "HQM_Spare22";
      HQM_Spare22->ValueDescription = "Spare22 value";
      HQM_Spare22->Values = "hqm_spare_reserved,Spare22";
      HQM_Spare22->IsMarketingValue = false;

      default_field HQM_Spare23 = 1'h0;
      HQM_Spare23->name = "HQM_Spare23";
      HQM_Spare23->ValueDescription = "Spare23 value";
      HQM_Spare23->Values = "hqm_spare_reserved,Spare23";
      HQM_Spare23->IsMarketingValue = false;

      default_field HQM_Spare24 = 1'h0;
      HQM_Spare24->name = "HQM_Spare24";
      HQM_Spare24->ValueDescription = "Spare24 value";
      HQM_Spare24->Values = "hqm_spare_reserved,Spare24";
      HQM_Spare24->IsMarketingValue = false;

      default_field HQM_Spare25 = 1'h0;
      HQM_Spare25->name = "HQM_Spare25";
      HQM_Spare25->ValueDescription = "Spare25 value";
      HQM_Spare25->Values = "hqm_spare_reserved,Spare25";
      HQM_Spare25->IsMarketingValue = false;

      default_field HQM_Spare26 = 1'h0;
      HQM_Spare26->name = "HQM_Spare26";
      HQM_Spare26->ValueDescription = "Spare26 value";
      HQM_Spare26->Values = "hqm_spare_reserved,Spare26";
      HQM_Spare26->IsMarketingValue = false;

      default_field HQM_Spare27 = 1'h0;
      HQM_Spare27->name = "HQM_Spare27";
      HQM_Spare27->ValueDescription = "Spare27 value";
      HQM_Spare27->Values = "hqm_spare_reserved,Spare27";
      HQM_Spare27->IsMarketingValue = false;

      default_field HQM_Spare28 = 1'h0;
      HQM_Spare28->name = "HQM_Spare28";
      HQM_Spare28->ValueDescription = "Spare28 value";
      HQM_Spare28->Values = "hqm_spare_reserved,Spare28";
      HQM_Spare28->IsMarketingValue = false;

      default_field HQM_Spare29 = 1'h0;
      HQM_Spare29->name = "HQM_Spare29";
      HQM_Spare29->ValueDescription = "Spare29 value";
      HQM_Spare29->Values = "hqm_spare_reserved,Spare29";
      HQM_Spare29->IsMarketingValue = false;

      default_field HQM_Spare30 = 1'h0;
      HQM_Spare30->name = "HQM_Spare30";
      HQM_Spare30->ValueDescription = "Spare30 value";
      HQM_Spare30->Values = "hqm_spare_reserved,Spare30";
      HQM_Spare30->IsMarketingValue = false;

      default_field HQM_Spare31 = 1'h0;
      HQM_Spare31->name = "HQM_Spare31";
      HQM_Spare31->ValueDescription = "Spare31 value";
      HQM_Spare31->Values = "hqm_spare_reserved,Spare31";
      HQM_Spare31->IsMarketingValue = false;

      default_field HQM_Spare32 = 1'h0;
      HQM_Spare32->name = "HQM_Spare32";
      HQM_Spare32->ValueDescription = "Spare32 value";
      HQM_Spare32->Values = "hqm_spare_reserved,Spare32";
      HQM_Spare32->IsMarketingValue = false;

      default_field HQM_Spare33 = 1'h0;
      HQM_Spare33->name = "HQM_Spare33";
      HQM_Spare33->ValueDescription = "Spare33 value";
      HQM_Spare33->Values = "hqm_spare_reserved,Spare33";
      HQM_Spare33->IsMarketingValue = false;

      default_field HQM_Spare34 = 1'h0;
      HQM_Spare34->name = "HQM_Spare34";
      HQM_Spare34->ValueDescription = "Spare34 value";
      HQM_Spare34->Values = "hqm_spare_reserved,Spare34";
      HQM_Spare34->IsMarketingValue = false;

      default_field HQM_Spare35 = 1'h0;
      HQM_Spare35->name = "HQM_Spare35";
      HQM_Spare35->ValueDescription = "Spare35 value";
      HQM_Spare35->Values = "hqm_spare_reserved,Spare35";
      HQM_Spare35->IsMarketingValue = false;

      default_field HQM_Spare36 = 1'h0;
      HQM_Spare36->name = "HQM_Spare36";
      HQM_Spare36->ValueDescription = "Spare36 value";
      HQM_Spare36->Values = "hqm_spare_reserved,Spare36";
      HQM_Spare36->IsMarketingValue = false;

      default_field HQM_Spare37 = 1'h0;
      HQM_Spare37->name = "HQM_Spare37";
      HQM_Spare37->ValueDescription = "Spare37 value";
      HQM_Spare37->Values = "hqm_spare_reserved,Spare37";
      HQM_Spare37->IsMarketingValue = false;

      default_field HQM_Spare38 = 1'h0;
      HQM_Spare38->name = "HQM_Spare38";
      HQM_Spare38->ValueDescription = "Spare38 value";
      HQM_Spare38->Values = "hqm_spare_reserved,Spare38";
      HQM_Spare38->IsMarketingValue = false;

      default_field HQM_Spare39 = 1'h0;
      HQM_Spare39->name = "HQM_Spare39";
      HQM_Spare39->ValueDescription = "Spare39 value";
      HQM_Spare39->Values = "hqm_spare_reserved,Spare39";
      HQM_Spare39->IsMarketingValue = false;

      default_field HQM_Spare40 = 1'h0;
      HQM_Spare40->name = "HQM_Spare40";
      HQM_Spare40->ValueDescription = "Spare40 value";
      HQM_Spare40->Values = "hqm_spare_reserved,Spare40";
      HQM_Spare40->IsMarketingValue = false;

      default_field HQM_Spare41 = 1'h0;
      HQM_Spare41->name = "HQM_Spare41";
      HQM_Spare41->ValueDescription = "Spare41 value";
      HQM_Spare41->Values = "hqm_spare_reserved,Spare41";
      HQM_Spare41->IsMarketingValue = false;

      default_field HQM_Spare42 = 1'h0;
      HQM_Spare42->name = "HQM_Spare42";
      HQM_Spare42->ValueDescription = "Spare42 value";
      HQM_Spare42->Values = "hqm_spare_reserved,Spare42";
      HQM_Spare42->IsMarketingValue = false;

      default_field HQM_Spare43 = 1'h0;
      HQM_Spare43->name = "HQM_Spare43";
      HQM_Spare43->ValueDescription = "Spare43 value";
      HQM_Spare43->Values = "hqm_spare_reserved,Spare43";
      HQM_Spare43->IsMarketingValue = false;

      default_field HQM_Spare44 = 1'h0;
      HQM_Spare44->name = "HQM_Spare44";
      HQM_Spare44->ValueDescription = "Spare44 value";
      HQM_Spare44->Values = "hqm_spare_reserved,Spare44";
      HQM_Spare44->IsMarketingValue = false;

      default_field HQM_Spare45 = 1'h0;
      HQM_Spare45->name = "HQM_Spare45";
      HQM_Spare45->ValueDescription = "Spare45 value";
      HQM_Spare45->Values = "hqm_spare_reserved,Spare45";
      HQM_Spare45->IsMarketingValue = false;

      default_field HQM_Spare46 = 1'h0;
      HQM_Spare46->name = "HQM_Spare46";
      HQM_Spare46->ValueDescription = "Spare46 value";
      HQM_Spare46->Values = "hqm_spare_reserved,Spare46";
      HQM_Spare46->IsMarketingValue = false;

      default_field HQM_Spare47 = 1'h0;
      HQM_Spare47->name = "HQM_Spare47";
      HQM_Spare47->ValueDescription = "Spare47 value";
      HQM_Spare47->Values = "hqm_spare_reserved,Spare47";
      HQM_Spare47->IsMarketingValue = false;

      default_field HQM_Spare48 = 1'h0;
      HQM_Spare48->name = "HQM_Spare48";
      HQM_Spare48->ValueDescription = "Spare48 value";
      HQM_Spare48->Values = "hqm_spare_reserved,Spare48";
      HQM_Spare48->IsMarketingValue = false;

      default_field HQM_Spare49 = 1'h0;
      HQM_Spare49->name = "HQM_Spare49";
      HQM_Spare49->ValueDescription = "Spare49 value";
      HQM_Spare49->Values = "hqm_spare_reserved,Spare49";
      HQM_Spare49->IsMarketingValue = false;

      default_field HQM_Spare50 = 1'h0;
      HQM_Spare50->name = "HQM_Spare50";
      HQM_Spare50->ValueDescription = "Spare50 value";
      HQM_Spare50->Values = "hqm_spare_reserved,Spare50";
      HQM_Spare50->IsMarketingValue = false;

      default_field HQM_Spare51 = 1'h0;
      HQM_Spare51->name = "HQM_Spare51";
      HQM_Spare51->ValueDescription = "Spare51 value";
      HQM_Spare51->Values = "hqm_spare_reserved,Spare51";
      HQM_Spare51->IsMarketingValue = false;

      default_field HQM_Spare52 = 1'h0;
      HQM_Spare52->name = "HQM_Spare52";
      HQM_Spare52->ValueDescription = "Spare52 value";
      HQM_Spare52->Values = "hqm_spare_reserved,Spare52";
      HQM_Spare52->IsMarketingValue = false;

      default_field HQM_Spare53 = 1'h0;
      HQM_Spare53->name = "HQM_Spare53";
      HQM_Spare53->ValueDescription = "Spare53 value";
      HQM_Spare53->Values = "hqm_spare_reserved,Spare53";
      HQM_Spare53->IsMarketingValue = false;

      default_field HQM_Spare54 = 1'h0;
      HQM_Spare54->name = "HQM_Spare54";
      HQM_Spare54->ValueDescription = "Spare54 value";
      HQM_Spare54->Values = "hqm_spare_reserved,Spare54";
      HQM_Spare54->IsMarketingValue = false;

      default_field HQM_Spare55 = 1'h0;
      HQM_Spare55->name = "HQM_Spare55";
      HQM_Spare55->ValueDescription = "Spare55 value";
      HQM_Spare55->Values = "hqm_spare_reserved,Spare55";
      HQM_Spare55->IsMarketingValue = false;

      default_field HQM_Spare56 = 1'h0;
      HQM_Spare56->name = "HQM_Spare56";
      HQM_Spare56->ValueDescription = "Spare56 value";
      HQM_Spare56->Values = "hqm_spare_reserved,Spare56";
      HQM_Spare56->IsMarketingValue = false;

      default_field HQM_Spare57 = 1'h0;
      HQM_Spare57->name = "HQM_Spare57";
      HQM_Spare57->ValueDescription = "Spare57 value";
      HQM_Spare57->Values = "hqm_spare_reserved,Spare57";
      HQM_Spare57->IsMarketingValue = false;

      default_field HQM_Spare58 = 1'h0;
      HQM_Spare58->name = "HQM_Spare58";
      HQM_Spare58->ValueDescription = "Spare58 value";
      HQM_Spare58->Values = "hqm_spare_reserved,Spare58";
      HQM_Spare58->IsMarketingValue = false;

      default_field HQM_Spare59 = 1'h0;
      HQM_Spare59->name = "HQM_Spare59";
      HQM_Spare59->ValueDescription = "Spare59 value";
      HQM_Spare59->Values = "hqm_spare_reserved,Spare59";
      HQM_Spare59->IsMarketingValue = false;

      default_field HQM_Spare60 = 1'h0;
      HQM_Spare60->name = "HQM_Spare60";
      HQM_Spare60->ValueDescription = "Spare60 value";
      HQM_Spare60->Values = "hqm_spare_reserved,Spare60";
      HQM_Spare60->IsMarketingValue = false;

      default_field HQM_Spare61 = 1'h0;
      HQM_Spare61->name = "HQM_Spare61";
      HQM_Spare61->ValueDescription = "Spare61 value";
      HQM_Spare61->Values = "hqm_spare_reserved,Spare61";
      HQM_Spare61->IsMarketingValue = false;

      default_field HQM_Spare62 = 1'h0;
      HQM_Spare62->name = "HQM_Spare62";
      HQM_Spare62->ValueDescription = "Spare62 value";
      HQM_Spare62->Values = "hqm_spare_reserved,Spare62";
      HQM_Spare62->IsMarketingValue = false;

      default_field HQM_Spare63 = 1'h0;
      HQM_Spare63->name = "HQM_Spare63";
      HQM_Spare63->ValueDescription = "Spare63 value";
      HQM_Spare63->Values = "hqm_spare_reserved,Spare63";
      HQM_Spare63->IsMarketingValue = false;
    };

    HQM_Spare HQM_Spare;

    reg HQM_Disable {
      regwidth = 32;  // make blueprint happy 

      ObjectType = "FEATURE";
      name = "HQM_Disable";
      FeatureDescription = "Disable the HQM";
      ResetValue = "HWResetConf";
      IsMarketingFeature = true;

      default_field HWResetConf = 1'h0;
      HWResetConf->name = "HWResetConf";
      HWResetConf->ValueDescription = "Reset value";
      HWResetConf->Values = "proc_disable,Enabled";
      HWResetConf->IsMarketingValue = false;

      default_field HQM_Enabled = 1'h0;
      HQM_Enabled->name = "HQM_Enabled";
      HQM_Enabled->ValueDescription = "HQM Enabled";
      HQM_Enabled->Values = "proc_disable,Enabled";
      HQM_Enabled->IsMarketingValue = true;

      default_field HQM_Disabled = 1'h0;
      HQM_Disabled->name = "HQM_Disabled";
      HQM_Disabled->ValueDescription = "HQM Disabled";
      HQM_Disabled->Values = "proc_disable,Disabled";
      HQM_Disabled->IsMarketingValue = true;
    };

    HQM_Disable HQM_Disable;

    reg HQM_Force_On {
      regwidth = 32;  // make blueprint happy 

      ObjectType = "FEATURE";
      name = "HQM_Force_On";
      FeatureDescription = "Force HQM power on";
      ResetValue = "HWResetConf";
      IsMarketingFeature = false;

      default_field HWResetConf = 1'h0;
      HWResetConf->name = "HWResetConf";
      HWResetConf->ValueDescription = "Reset value";
      HWResetConf->Values = "force_on,NoForce";
      HWResetConf->IsMarketingValue = false;

      default_field HQM_NoForce = 1'h0;
      HQM_NoForce->name = "HQM_NoForce";
      HQM_NoForce->ValueDescription = "HQM will dynamically powergate";
      HQM_NoForce->Values = "force_on,NoForce";
      HQM_NoForce->IsMarketingValue = false;

      default_field HQM_ForceOn = 1'h0;
      HQM_ForceOn->name = "HQM_ForceOn";
      HQM_ForceOn->ValueDescription = "HQM forced on";
      HQM_ForceOn->Values = "force_on,ForceOn";
      HQM_ForceOn->IsMarketingValue = false;
    };

    HQM_Force_On HQM_Force_On;

    reg HQM_Revision {
      regwidth = 512;  // make blueprint happy 

      ObjectType = "FEATURE";
      name = "HQM_Revision";
      FeatureDescription = "HQM revision";
      ResetValue = "HWResetConf";
      IsMarketingFeature = false;

      default_field HWResetConf = 1'h0;
      HWResetConf->name = "HWResetConf";
      HWResetConf->ValueDescription = "Reset value";
      HWResetConf->Values = "revision_id,Revision0";
      HWResetConf->IsMarketingValue = false;

      default_field Revision0 = 1'h0;
      Revision0->name = "Revision0";
      Revision0->ValueDescription = "HQM Revision ID";
      Revision0->Values = "revision_id,Revision0";
      Revision0->IsMarketingValue = false;

      default_field Revision1 = 1'h0;
      Revision1->name = "Revision1";
      Revision1->ValueDescription = "HQM Revision ID";
      Revision1->Values = "revision_id,Revision1";
      Revision1->IsMarketingValue = false;

      default_field Revision2 = 1'h0;
      Revision2->name = "Revision2";
      Revision2->ValueDescription = "HQM Revision ID";
      Revision2->Values = "revision_id,Revision2";
      Revision2->IsMarketingValue = false;

      default_field Revision3 = 1'h0;
      Revision3->name = "Revision3";
      Revision3->ValueDescription = "HQM Revision ID";
      Revision3->Values = "revision_id,Revision3";
      Revision3->IsMarketingValue = false;

      default_field Revision4 = 1'h0;
      Revision4->name = "Revision4";
      Revision4->ValueDescription = "HQM Revision ID";
      Revision4->Values = "revision_id,Revision4";
      Revision4->IsMarketingValue = false;

      default_field Revision5 = 1'h0;
      Revision5->name = "Revision5";
      Revision5->ValueDescription = "HQM Revision ID";
      Revision5->Values = "revision_id,Revision5";
      Revision5->IsMarketingValue = false;

      default_field Revision6 = 1'h0;
      Revision6->name = "Revision6";
      Revision6->ValueDescription = "HQM Revision ID";
      Revision6->Values = "revision_id,Revision6";
      Revision6->IsMarketingValue = false;

      default_field Revision7 = 1'h0;
      Revision7->name = "Revision7";
      Revision7->ValueDescription = "HQM Revision ID";
      Revision7->Values = "revision_id,Revision7";
      Revision7->IsMarketingValue = false;

      default_field Revision8 = 1'h0;
      Revision8->name = "Revision8";
      Revision8->ValueDescription = "HQM Revision ID";
      Revision8->Values = "revision_id,Revision8";
      Revision8->IsMarketingValue = false;

      default_field Revision9 = 1'h0;
      Revision9->name = "Revision9";
      Revision9->ValueDescription = "HQM Revision ID";
      Revision9->Values = "revision_id,Revision9";
      Revision9->IsMarketingValue = false;

      default_field Revision10 = 1'h0;
      Revision10->name = "Revision10";
      Revision10->ValueDescription = "HQM Revision ID";
      Revision10->Values = "revision_id,Revision10";
      Revision10->IsMarketingValue = false;

      default_field Revision11 = 1'h0;
      Revision11->name = "Revision11";
      Revision11->ValueDescription = "HQM Revision ID";
      Revision11->Values = "revision_id,Revision11";
      Revision11->IsMarketingValue = false;

      default_field Revision12 = 1'h0;
      Revision12->name = "Revision12";
      Revision12->ValueDescription = "HQM Revision ID";
      Revision12->Values = "revision_id,Revision12";
      Revision12->IsMarketingValue = false;

      default_field Revision13 = 1'h0;
      Revision13->name = "Revision13";
      Revision13->ValueDescription = "HQM Revision ID";
      Revision13->Values = "revision_id,Revision13";
      Revision13->IsMarketingValue = false;

      default_field Revision14 = 1'h0;
      Revision14->name = "Revision14";
      Revision14->ValueDescription = "HQM Revision ID";
      Revision14->Values = "revision_id,Revision14";
      Revision14->IsMarketingValue = false;

      default_field Revision15 = 1'h0;
      Revision15->name = "Revision15";
      Revision15->ValueDescription = "HQM Revision ID";
      Revision15->Values = "revision_id,Revision15";
      Revision15->IsMarketingValue = false;

      default_field Revision16 = 1'h0;
      Revision16->name = "Revision16";
      Revision16->ValueDescription = "HQM Revision ID";
      Revision16->Values = "revision_id,Revision16";
      Revision16->IsMarketingValue = false;

      default_field Revision17 = 1'h0;
      Revision17->name = "Revision17";
      Revision17->ValueDescription = "HQM Revision ID";
      Revision17->Values = "revision_id,Revision17";
      Revision17->IsMarketingValue = false;

      default_field Revision18 = 1'h0;
      Revision18->name = "Revision18";
      Revision18->ValueDescription = "HQM Revision ID";
      Revision18->Values = "revision_id,Revision18";
      Revision18->IsMarketingValue = false;

      default_field Revision19 = 1'h0;
      Revision19->name = "Revision19";
      Revision19->ValueDescription = "HQM Revision ID";
      Revision19->Values = "revision_id,Revision19";
      Revision19->IsMarketingValue = false;

      default_field Revision20 = 1'h0;
      Revision20->name = "Revision20";
      Revision20->ValueDescription = "HQM Revision ID";
      Revision20->Values = "revision_id,Revision20";
      Revision20->IsMarketingValue = false;

      default_field Revision21 = 1'h0;
      Revision21->name = "Revision21";
      Revision21->ValueDescription = "HQM Revision ID";
      Revision21->Values = "revision_id,Revision21";
      Revision21->IsMarketingValue = false;

      default_field Revision22 = 1'h0;
      Revision22->name = "Revision22";
      Revision22->ValueDescription = "HQM Revision ID";
      Revision22->Values = "revision_id,Revision22";
      Revision22->IsMarketingValue = false;

      default_field Revision23 = 1'h0;
      Revision23->name = "Revision23";
      Revision23->ValueDescription = "HQM Revision ID";
      Revision23->Values = "revision_id,Revision23";
      Revision23->IsMarketingValue = false;

      default_field Revision24 = 1'h0;
      Revision24->name = "Revision24";
      Revision24->ValueDescription = "HQM Revision ID";
      Revision24->Values = "revision_id,Revision24";
      Revision24->IsMarketingValue = false;

      default_field Revision25 = 1'h0;
      Revision25->name = "Revision25";
      Revision25->ValueDescription = "HQM Revision ID";
      Revision25->Values = "revision_id,Revision25";
      Revision25->IsMarketingValue = false;

      default_field Revision26 = 1'h0;
      Revision26->name = "Revision26";
      Revision26->ValueDescription = "HQM Revision ID";
      Revision26->Values = "revision_id,Revision26";
      Revision26->IsMarketingValue = false;

      default_field Revision27 = 1'h0;
      Revision27->name = "Revision27";
      Revision27->ValueDescription = "HQM Revision ID";
      Revision27->Values = "revision_id,Revision27";
      Revision27->IsMarketingValue = false;

      default_field Revision28 = 1'h0;
      Revision28->name = "Revision28";
      Revision28->ValueDescription = "HQM Revision ID";
      Revision28->Values = "revision_id,Revision28";
      Revision28->IsMarketingValue = false;

      default_field Revision29 = 1'h0;
      Revision29->name = "Revision29";
      Revision29->ValueDescription = "HQM Revision ID";
      Revision29->Values = "revision_id,Revision29";
      Revision29->IsMarketingValue = false;

      default_field Revision30 = 1'h0;
      Revision30->name = "Revision30";
      Revision30->ValueDescription = "HQM Revision ID";
      Revision30->Values = "revision_id,Revision30";
      Revision30->IsMarketingValue = false;

      default_field Revision31 = 1'h0;
      Revision31->name = "Revision31";
      Revision31->ValueDescription = "HQM Revision ID";
      Revision31->Values = "revision_id,Revision31";
      Revision31->IsMarketingValue = false;

      default_field Revision32 = 1'h0;
      Revision32->name = "Revision32";
      Revision32->ValueDescription = "HQM Revision ID";
      Revision32->Values = "revision_id,Revision32";
      Revision32->IsMarketingValue = false;

      default_field Revision33 = 1'h0;
      Revision33->name = "Revision33";
      Revision33->ValueDescription = "HQM Revision ID";
      Revision33->Values = "revision_id,Revision33";
      Revision33->IsMarketingValue = false;

      default_field Revision34 = 1'h0;
      Revision34->name = "Revision34";
      Revision34->ValueDescription = "HQM Revision ID";
      Revision34->Values = "revision_id,Revision34";
      Revision34->IsMarketingValue = false;

      default_field Revision35 = 1'h0;
      Revision35->name = "Revision35";
      Revision35->ValueDescription = "HQM Revision ID";
      Revision35->Values = "revision_id,Revision35";
      Revision35->IsMarketingValue = false;

      default_field Revision36 = 1'h0;
      Revision36->name = "Revision36";
      Revision36->ValueDescription = "HQM Revision ID";
      Revision36->Values = "revision_id,Revision36";
      Revision36->IsMarketingValue = false;

      default_field Revision37 = 1'h0;
      Revision37->name = "Revision37";
      Revision37->ValueDescription = "HQM Revision ID";
      Revision37->Values = "revision_id,Revision37";
      Revision37->IsMarketingValue = false;

      default_field Revision38 = 1'h0;
      Revision38->name = "Revision38";
      Revision38->ValueDescription = "HQM Revision ID";
      Revision38->Values = "revision_id,Revision38";
      Revision38->IsMarketingValue = false;

      default_field Revision39 = 1'h0;
      Revision39->name = "Revision39";
      Revision39->ValueDescription = "HQM Revision ID";
      Revision39->Values = "revision_id,Revision39";
      Revision39->IsMarketingValue = false;

      default_field Revision40 = 1'h0;
      Revision40->name = "Revision40";
      Revision40->ValueDescription = "HQM Revision ID";
      Revision40->Values = "revision_id,Revision40";
      Revision40->IsMarketingValue = false;

      default_field Revision41 = 1'h0;
      Revision41->name = "Revision41";
      Revision41->ValueDescription = "HQM Revision ID";
      Revision41->Values = "revision_id,Revision41";
      Revision41->IsMarketingValue = false;

      default_field Revision42 = 1'h0;
      Revision42->name = "Revision42";
      Revision42->ValueDescription = "HQM Revision ID";
      Revision42->Values = "revision_id,Revision42";
      Revision42->IsMarketingValue = false;

      default_field Revision43 = 1'h0;
      Revision43->name = "Revision43";
      Revision43->ValueDescription = "HQM Revision ID";
      Revision43->Values = "revision_id,Revision43";
      Revision43->IsMarketingValue = false;

      default_field Revision44 = 1'h0;
      Revision44->name = "Revision44";
      Revision44->ValueDescription = "HQM Revision ID";
      Revision44->Values = "revision_id,Revision44";
      Revision44->IsMarketingValue = false;

      default_field Revision45 = 1'h0;
      Revision45->name = "Revision45";
      Revision45->ValueDescription = "HQM Revision ID";
      Revision45->Values = "revision_id,Revision45";
      Revision45->IsMarketingValue = false;

      default_field Revision46 = 1'h0;
      Revision46->name = "Revision46";
      Revision46->ValueDescription = "HQM Revision ID";
      Revision46->Values = "revision_id,Revision46";
      Revision46->IsMarketingValue = false;

      default_field Revision47 = 1'h0;
      Revision47->name = "Revision47";
      Revision47->ValueDescription = "HQM Revision ID";
      Revision47->Values = "revision_id,Revision47";
      Revision47->IsMarketingValue = false;

      default_field Revision48 = 1'h0;
      Revision48->name = "Revision48";
      Revision48->ValueDescription = "HQM Revision ID";
      Revision48->Values = "revision_id,Revision48";
      Revision48->IsMarketingValue = false;

      default_field Revision49 = 1'h0;
      Revision49->name = "Revision49";
      Revision49->ValueDescription = "HQM Revision ID";
      Revision49->Values = "revision_id,Revision49";
      Revision49->IsMarketingValue = false;

      default_field Revision50 = 1'h0;
      Revision50->name = "Revision50";
      Revision50->ValueDescription = "HQM Revision ID";
      Revision50->Values = "revision_id,Revision50";
      Revision50->IsMarketingValue = false;

      default_field Revision51 = 1'h0;
      Revision51->name = "Revision51";
      Revision51->ValueDescription = "HQM Revision ID";
      Revision51->Values = "revision_id,Revision51";
      Revision51->IsMarketingValue = false;

      default_field Revision52 = 1'h0;
      Revision52->name = "Revision52";
      Revision52->ValueDescription = "HQM Revision ID";
      Revision52->Values = "revision_id,Revision52";
      Revision52->IsMarketingValue = false;

      default_field Revision53 = 1'h0;
      Revision53->name = "Revision53";
      Revision53->ValueDescription = "HQM Revision ID";
      Revision53->Values = "revision_id,Revision53";
      Revision53->IsMarketingValue = false;

      default_field Revision54 = 1'h0;
      Revision54->name = "Revision54";
      Revision54->ValueDescription = "HQM Revision ID";
      Revision54->Values = "revision_id,Revision54";
      Revision54->IsMarketingValue = false;

      default_field Revision55 = 1'h0;
      Revision55->name = "Revision55";
      Revision55->ValueDescription = "HQM Revision ID";
      Revision55->Values = "revision_id,Revision55";
      Revision55->IsMarketingValue = false;

      default_field Revision56 = 1'h0;
      Revision56->name = "Revision56";
      Revision56->ValueDescription = "HQM Revision ID";
      Revision56->Values = "revision_id,Revision56";
      Revision56->IsMarketingValue = false;

      default_field Revision57 = 1'h0;
      Revision57->name = "Revision57";
      Revision57->ValueDescription = "HQM Revision ID";
      Revision57->Values = "revision_id,Revision57";
      Revision57->IsMarketingValue = false;

      default_field Revision58 = 1'h0;
      Revision58->name = "Revision58";
      Revision58->ValueDescription = "HQM Revision ID";
      Revision58->Values = "revision_id,Revision58";
      Revision58->IsMarketingValue = false;

      default_field Revision59 = 1'h0;
      Revision59->name = "Revision59";
      Revision59->ValueDescription = "HQM Revision ID";
      Revision59->Values = "revision_id,Revision59";
      Revision59->IsMarketingValue = false;

      default_field Revision60 = 1'h0;
      Revision60->name = "Revision60";
      Revision60->ValueDescription = "HQM Revision ID";
      Revision60->Values = "revision_id,Revision60";
      Revision60->IsMarketingValue = false;

      default_field Revision61 = 1'h0;
      Revision61->name = "Revision61";
      Revision61->ValueDescription = "HQM Revision ID";
      Revision61->Values = "revision_id,Revision61";
      Revision61->IsMarketingValue = false;

      default_field Revision62 = 1'h0;
      Revision62->name = "Revision62";
      Revision62->ValueDescription = "HQM Revision ID";
      Revision62->Values = "revision_id,Revision62";
      Revision62->IsMarketingValue = false;

      default_field Revision63 = 1'h0;
      Revision63->name = "Revision63";
      Revision63->ValueDescription = "HQM Revision ID";
      Revision63->Values = "revision_id,Revision63";
      Revision63->IsMarketingValue = false;

      default_field Revision64 = 1'h0;
      Revision64->name = "Revision64";
      Revision64->ValueDescription = "HQM Revision ID";
      Revision64->Values = "revision_id,Revision64";
      Revision64->IsMarketingValue = false;

      default_field Revision65 = 1'h0;
      Revision65->name = "Revision65";
      Revision65->ValueDescription = "HQM Revision ID";
      Revision65->Values = "revision_id,Revision65";
      Revision65->IsMarketingValue = false;

      default_field Revision66 = 1'h0;
      Revision66->name = "Revision66";
      Revision66->ValueDescription = "HQM Revision ID";
      Revision66->Values = "revision_id,Revision66";
      Revision66->IsMarketingValue = false;

      default_field Revision67 = 1'h0;
      Revision67->name = "Revision67";
      Revision67->ValueDescription = "HQM Revision ID";
      Revision67->Values = "revision_id,Revision67";
      Revision67->IsMarketingValue = false;

      default_field Revision68 = 1'h0;
      Revision68->name = "Revision68";
      Revision68->ValueDescription = "HQM Revision ID";
      Revision68->Values = "revision_id,Revision68";
      Revision68->IsMarketingValue = false;

      default_field Revision69 = 1'h0;
      Revision69->name = "Revision69";
      Revision69->ValueDescription = "HQM Revision ID";
      Revision69->Values = "revision_id,Revision69";
      Revision69->IsMarketingValue = false;

      default_field Revision70 = 1'h0;
      Revision70->name = "Revision70";
      Revision70->ValueDescription = "HQM Revision ID";
      Revision70->Values = "revision_id,Revision70";
      Revision70->IsMarketingValue = false;

      default_field Revision71 = 1'h0;
      Revision71->name = "Revision71";
      Revision71->ValueDescription = "HQM Revision ID";
      Revision71->Values = "revision_id,Revision71";
      Revision71->IsMarketingValue = false;

      default_field Revision72 = 1'h0;
      Revision72->name = "Revision72";
      Revision72->ValueDescription = "HQM Revision ID";
      Revision72->Values = "revision_id,Revision72";
      Revision72->IsMarketingValue = false;

      default_field Revision73 = 1'h0;
      Revision73->name = "Revision73";
      Revision73->ValueDescription = "HQM Revision ID";
      Revision73->Values = "revision_id,Revision73";
      Revision73->IsMarketingValue = false;

      default_field Revision74 = 1'h0;
      Revision74->name = "Revision74";
      Revision74->ValueDescription = "HQM Revision ID";
      Revision74->Values = "revision_id,Revision74";
      Revision74->IsMarketingValue = false;

      default_field Revision75 = 1'h0;
      Revision75->name = "Revision75";
      Revision75->ValueDescription = "HQM Revision ID";
      Revision75->Values = "revision_id,Revision75";
      Revision75->IsMarketingValue = false;

      default_field Revision76 = 1'h0;
      Revision76->name = "Revision76";
      Revision76->ValueDescription = "HQM Revision ID";
      Revision76->Values = "revision_id,Revision76";
      Revision76->IsMarketingValue = false;

      default_field Revision77 = 1'h0;
      Revision77->name = "Revision77";
      Revision77->ValueDescription = "HQM Revision ID";
      Revision77->Values = "revision_id,Revision77";
      Revision77->IsMarketingValue = false;

      default_field Revision78 = 1'h0;
      Revision78->name = "Revision78";
      Revision78->ValueDescription = "HQM Revision ID";
      Revision78->Values = "revision_id,Revision78";
      Revision78->IsMarketingValue = false;

      default_field Revision79 = 1'h0;
      Revision79->name = "Revision79";
      Revision79->ValueDescription = "HQM Revision ID";
      Revision79->Values = "revision_id,Revision79";
      Revision79->IsMarketingValue = false;

      default_field Revision80 = 1'h0;
      Revision80->name = "Revision80";
      Revision80->ValueDescription = "HQM Revision ID";
      Revision80->Values = "revision_id,Revision80";
      Revision80->IsMarketingValue = false;

      default_field Revision81 = 1'h0;
      Revision81->name = "Revision81";
      Revision81->ValueDescription = "HQM Revision ID";
      Revision81->Values = "revision_id,Revision81";
      Revision81->IsMarketingValue = false;

      default_field Revision82 = 1'h0;
      Revision82->name = "Revision82";
      Revision82->ValueDescription = "HQM Revision ID";
      Revision82->Values = "revision_id,Revision82";
      Revision82->IsMarketingValue = false;

      default_field Revision83 = 1'h0;
      Revision83->name = "Revision83";
      Revision83->ValueDescription = "HQM Revision ID";
      Revision83->Values = "revision_id,Revision83";
      Revision83->IsMarketingValue = false;

      default_field Revision84 = 1'h0;
      Revision84->name = "Revision84";
      Revision84->ValueDescription = "HQM Revision ID";
      Revision84->Values = "revision_id,Revision84";
      Revision84->IsMarketingValue = false;

      default_field Revision85 = 1'h0;
      Revision85->name = "Revision85";
      Revision85->ValueDescription = "HQM Revision ID";
      Revision85->Values = "revision_id,Revision85";
      Revision85->IsMarketingValue = false;

      default_field Revision86 = 1'h0;
      Revision86->name = "Revision86";
      Revision86->ValueDescription = "HQM Revision ID";
      Revision86->Values = "revision_id,Revision86";
      Revision86->IsMarketingValue = false;

      default_field Revision87 = 1'h0;
      Revision87->name = "Revision87";
      Revision87->ValueDescription = "HQM Revision ID";
      Revision87->Values = "revision_id,Revision87";
      Revision87->IsMarketingValue = false;

      default_field Revision88 = 1'h0;
      Revision88->name = "Revision88";
      Revision88->ValueDescription = "HQM Revision ID";
      Revision88->Values = "revision_id,Revision88";
      Revision88->IsMarketingValue = false;

      default_field Revision89 = 1'h0;
      Revision89->name = "Revision89";
      Revision89->ValueDescription = "HQM Revision ID";
      Revision89->Values = "revision_id,Revision89";
      Revision89->IsMarketingValue = false;

      default_field Revision90 = 1'h0;
      Revision90->name = "Revision90";
      Revision90->ValueDescription = "HQM Revision ID";
      Revision90->Values = "revision_id,Revision90";
      Revision90->IsMarketingValue = false;

      default_field Revision91 = 1'h0;
      Revision91->name = "Revision91";
      Revision91->ValueDescription = "HQM Revision ID";
      Revision91->Values = "revision_id,Revision91";
      Revision91->IsMarketingValue = false;

      default_field Revision92 = 1'h0;
      Revision92->name = "Revision92";
      Revision92->ValueDescription = "HQM Revision ID";
      Revision92->Values = "revision_id,Revision92";
      Revision92->IsMarketingValue = false;

      default_field Revision93 = 1'h0;
      Revision93->name = "Revision93";
      Revision93->ValueDescription = "HQM Revision ID";
      Revision93->Values = "revision_id,Revision93";
      Revision93->IsMarketingValue = false;

      default_field Revision94 = 1'h0;
      Revision94->name = "Revision94";
      Revision94->ValueDescription = "HQM Revision ID";
      Revision94->Values = "revision_id,Revision94";
      Revision94->IsMarketingValue = false;

      default_field Revision95 = 1'h0;
      Revision95->name = "Revision95";
      Revision95->ValueDescription = "HQM Revision ID";
      Revision95->Values = "revision_id,Revision95";
      Revision95->IsMarketingValue = false;

      default_field Revision96 = 1'h0;
      Revision96->name = "Revision96";
      Revision96->ValueDescription = "HQM Revision ID";
      Revision96->Values = "revision_id,Revision96";
      Revision96->IsMarketingValue = false;

      default_field Revision97 = 1'h0;
      Revision97->name = "Revision97";
      Revision97->ValueDescription = "HQM Revision ID";
      Revision97->Values = "revision_id,Revision97";
      Revision97->IsMarketingValue = false;

      default_field Revision98 = 1'h0;
      Revision98->name = "Revision98";
      Revision98->ValueDescription = "HQM Revision ID";
      Revision98->Values = "revision_id,Revision98";
      Revision98->IsMarketingValue = false;

      default_field Revision99 = 1'h0;
      Revision99->name = "Revision99";
      Revision99->ValueDescription = "HQM Revision ID";
      Revision99->Values = "revision_id,Revision99";
      Revision99->IsMarketingValue = false;

      default_field Revision100 = 1'h0;
      Revision100->name = "Revision100";
      Revision100->ValueDescription = "HQM Revision ID";
      Revision100->Values = "revision_id,Revision100";
      Revision100->IsMarketingValue = false;

      default_field Revision101 = 1'h0;
      Revision101->name = "Revision101";
      Revision101->ValueDescription = "HQM Revision ID";
      Revision101->Values = "revision_id,Revision101";
      Revision101->IsMarketingValue = false;

      default_field Revision102 = 1'h0;
      Revision102->name = "Revision102";
      Revision102->ValueDescription = "HQM Revision ID";
      Revision102->Values = "revision_id,Revision102";
      Revision102->IsMarketingValue = false;

      default_field Revision103 = 1'h0;
      Revision103->name = "Revision103";
      Revision103->ValueDescription = "HQM Revision ID";
      Revision103->Values = "revision_id,Revision103";
      Revision103->IsMarketingValue = false;

      default_field Revision104 = 1'h0;
      Revision104->name = "Revision104";
      Revision104->ValueDescription = "HQM Revision ID";
      Revision104->Values = "revision_id,Revision104";
      Revision104->IsMarketingValue = false;

      default_field Revision105 = 1'h0;
      Revision105->name = "Revision105";
      Revision105->ValueDescription = "HQM Revision ID";
      Revision105->Values = "revision_id,Revision105";
      Revision105->IsMarketingValue = false;

      default_field Revision106 = 1'h0;
      Revision106->name = "Revision106";
      Revision106->ValueDescription = "HQM Revision ID";
      Revision106->Values = "revision_id,Revision106";
      Revision106->IsMarketingValue = false;

      default_field Revision107 = 1'h0;
      Revision107->name = "Revision107";
      Revision107->ValueDescription = "HQM Revision ID";
      Revision107->Values = "revision_id,Revision107";
      Revision107->IsMarketingValue = false;

      default_field Revision108 = 1'h0;
      Revision108->name = "Revision108";
      Revision108->ValueDescription = "HQM Revision ID";
      Revision108->Values = "revision_id,Revision108";
      Revision108->IsMarketingValue = false;

      default_field Revision109 = 1'h0;
      Revision109->name = "Revision109";
      Revision109->ValueDescription = "HQM Revision ID";
      Revision109->Values = "revision_id,Revision109";
      Revision109->IsMarketingValue = false;

      default_field Revision110 = 1'h0;
      Revision110->name = "Revision110";
      Revision110->ValueDescription = "HQM Revision ID";
      Revision110->Values = "revision_id,Revision110";
      Revision110->IsMarketingValue = false;

      default_field Revision111 = 1'h0;
      Revision111->name = "Revision111";
      Revision111->ValueDescription = "HQM Revision ID";
      Revision111->Values = "revision_id,Revision111";
      Revision111->IsMarketingValue = false;

      default_field Revision112 = 1'h0;
      Revision112->name = "Revision112";
      Revision112->ValueDescription = "HQM Revision ID";
      Revision112->Values = "revision_id,Revision112";
      Revision112->IsMarketingValue = false;

      default_field Revision113 = 1'h0;
      Revision113->name = "Revision113";
      Revision113->ValueDescription = "HQM Revision ID";
      Revision113->Values = "revision_id,Revision113";
      Revision113->IsMarketingValue = false;

      default_field Revision114 = 1'h0;
      Revision114->name = "Revision114";
      Revision114->ValueDescription = "HQM Revision ID";
      Revision114->Values = "revision_id,Revision114";
      Revision114->IsMarketingValue = false;

      default_field Revision115 = 1'h0;
      Revision115->name = "Revision115";
      Revision115->ValueDescription = "HQM Revision ID";
      Revision115->Values = "revision_id,Revision115";
      Revision115->IsMarketingValue = false;

      default_field Revision116 = 1'h0;
      Revision116->name = "Revision116";
      Revision116->ValueDescription = "HQM Revision ID";
      Revision116->Values = "revision_id,Revision116";
      Revision116->IsMarketingValue = false;

      default_field Revision117 = 1'h0;
      Revision117->name = "Revision117";
      Revision117->ValueDescription = "HQM Revision ID";
      Revision117->Values = "revision_id,Revision117";
      Revision117->IsMarketingValue = false;

      default_field Revision118 = 1'h0;
      Revision118->name = "Revision118";
      Revision118->ValueDescription = "HQM Revision ID";
      Revision118->Values = "revision_id,Revision118";
      Revision118->IsMarketingValue = false;

      default_field Revision119 = 1'h0;
      Revision119->name = "Revision119";
      Revision119->ValueDescription = "HQM Revision ID";
      Revision119->Values = "revision_id,Revision119";
      Revision119->IsMarketingValue = false;

      default_field Revision120 = 1'h0;
      Revision120->name = "Revision120";
      Revision120->ValueDescription = "HQM Revision ID";
      Revision120->Values = "revision_id,Revision120";
      Revision120->IsMarketingValue = false;

      default_field Revision121 = 1'h0;
      Revision121->name = "Revision121";
      Revision121->ValueDescription = "HQM Revision ID";
      Revision121->Values = "revision_id,Revision121";
      Revision121->IsMarketingValue = false;

      default_field Revision122 = 1'h0;
      Revision122->name = "Revision122";
      Revision122->ValueDescription = "HQM Revision ID";
      Revision122->Values = "revision_id,Revision122";
      Revision122->IsMarketingValue = false;

      default_field Revision123 = 1'h0;
      Revision123->name = "Revision123";
      Revision123->ValueDescription = "HQM Revision ID";
      Revision123->Values = "revision_id,Revision123";
      Revision123->IsMarketingValue = false;

      default_field Revision124 = 1'h0;
      Revision124->name = "Revision124";
      Revision124->ValueDescription = "HQM Revision ID";
      Revision124->Values = "revision_id,Revision124";
      Revision124->IsMarketingValue = false;

      default_field Revision125 = 1'h0;
      Revision125->name = "Revision125";
      Revision125->ValueDescription = "HQM Revision ID";
      Revision125->Values = "revision_id,Revision125";
      Revision125->IsMarketingValue = false;

      default_field Revision126 = 1'h0;
      Revision126->name = "Revision126";
      Revision126->ValueDescription = "HQM Revision ID";
      Revision126->Values = "revision_id,Revision126";
      Revision126->IsMarketingValue = false;

      default_field Revision127 = 1'h0;
      Revision127->name = "Revision127";
      Revision127->ValueDescription = "HQM Revision ID";
      Revision127->Values = "revision_id,Revision127";
      Revision127->IsMarketingValue = false;

      default_field Revision128 = 1'h0;
      Revision128->name = "Revision128";
      Revision128->ValueDescription = "HQM Revision ID";
      Revision128->Values = "revision_id,Revision128";
      Revision128->IsMarketingValue = false;

      default_field Revision129 = 1'h0;
      Revision129->name = "Revision129";
      Revision129->ValueDescription = "HQM Revision ID";
      Revision129->Values = "revision_id,Revision129";
      Revision129->IsMarketingValue = false;

      default_field Revision130 = 1'h0;
      Revision130->name = "Revision130";
      Revision130->ValueDescription = "HQM Revision ID";
      Revision130->Values = "revision_id,Revision130";
      Revision130->IsMarketingValue = false;

      default_field Revision131 = 1'h0;
      Revision131->name = "Revision131";
      Revision131->ValueDescription = "HQM Revision ID";
      Revision131->Values = "revision_id,Revision131";
      Revision131->IsMarketingValue = false;

      default_field Revision132 = 1'h0;
      Revision132->name = "Revision132";
      Revision132->ValueDescription = "HQM Revision ID";
      Revision132->Values = "revision_id,Revision132";
      Revision132->IsMarketingValue = false;

      default_field Revision133 = 1'h0;
      Revision133->name = "Revision133";
      Revision133->ValueDescription = "HQM Revision ID";
      Revision133->Values = "revision_id,Revision133";
      Revision133->IsMarketingValue = false;

      default_field Revision134 = 1'h0;
      Revision134->name = "Revision134";
      Revision134->ValueDescription = "HQM Revision ID";
      Revision134->Values = "revision_id,Revision134";
      Revision134->IsMarketingValue = false;

      default_field Revision135 = 1'h0;
      Revision135->name = "Revision135";
      Revision135->ValueDescription = "HQM Revision ID";
      Revision135->Values = "revision_id,Revision135";
      Revision135->IsMarketingValue = false;

      default_field Revision136 = 1'h0;
      Revision136->name = "Revision136";
      Revision136->ValueDescription = "HQM Revision ID";
      Revision136->Values = "revision_id,Revision136";
      Revision136->IsMarketingValue = false;

      default_field Revision137 = 1'h0;
      Revision137->name = "Revision137";
      Revision137->ValueDescription = "HQM Revision ID";
      Revision137->Values = "revision_id,Revision137";
      Revision137->IsMarketingValue = false;

      default_field Revision138 = 1'h0;
      Revision138->name = "Revision138";
      Revision138->ValueDescription = "HQM Revision ID";
      Revision138->Values = "revision_id,Revision138";
      Revision138->IsMarketingValue = false;

      default_field Revision139 = 1'h0;
      Revision139->name = "Revision139";
      Revision139->ValueDescription = "HQM Revision ID";
      Revision139->Values = "revision_id,Revision139";
      Revision139->IsMarketingValue = false;

      default_field Revision140 = 1'h0;
      Revision140->name = "Revision140";
      Revision140->ValueDescription = "HQM Revision ID";
      Revision140->Values = "revision_id,Revision140";
      Revision140->IsMarketingValue = false;

      default_field Revision141 = 1'h0;
      Revision141->name = "Revision141";
      Revision141->ValueDescription = "HQM Revision ID";
      Revision141->Values = "revision_id,Revision141";
      Revision141->IsMarketingValue = false;

      default_field Revision142 = 1'h0;
      Revision142->name = "Revision142";
      Revision142->ValueDescription = "HQM Revision ID";
      Revision142->Values = "revision_id,Revision142";
      Revision142->IsMarketingValue = false;

      default_field Revision143 = 1'h0;
      Revision143->name = "Revision143";
      Revision143->ValueDescription = "HQM Revision ID";
      Revision143->Values = "revision_id,Revision143";
      Revision143->IsMarketingValue = false;

      default_field Revision144 = 1'h0;
      Revision144->name = "Revision144";
      Revision144->ValueDescription = "HQM Revision ID";
      Revision144->Values = "revision_id,Revision144";
      Revision144->IsMarketingValue = false;

      default_field Revision145 = 1'h0;
      Revision145->name = "Revision145";
      Revision145->ValueDescription = "HQM Revision ID";
      Revision145->Values = "revision_id,Revision145";
      Revision145->IsMarketingValue = false;

      default_field Revision146 = 1'h0;
      Revision146->name = "Revision146";
      Revision146->ValueDescription = "HQM Revision ID";
      Revision146->Values = "revision_id,Revision146";
      Revision146->IsMarketingValue = false;

      default_field Revision147 = 1'h0;
      Revision147->name = "Revision147";
      Revision147->ValueDescription = "HQM Revision ID";
      Revision147->Values = "revision_id,Revision147";
      Revision147->IsMarketingValue = false;

      default_field Revision148 = 1'h0;
      Revision148->name = "Revision148";
      Revision148->ValueDescription = "HQM Revision ID";
      Revision148->Values = "revision_id,Revision148";
      Revision148->IsMarketingValue = false;

      default_field Revision149 = 1'h0;
      Revision149->name = "Revision149";
      Revision149->ValueDescription = "HQM Revision ID";
      Revision149->Values = "revision_id,Revision149";
      Revision149->IsMarketingValue = false;

      default_field Revision150 = 1'h0;
      Revision150->name = "Revision150";
      Revision150->ValueDescription = "HQM Revision ID";
      Revision150->Values = "revision_id,Revision150";
      Revision150->IsMarketingValue = false;

      default_field Revision151 = 1'h0;
      Revision151->name = "Revision151";
      Revision151->ValueDescription = "HQM Revision ID";
      Revision151->Values = "revision_id,Revision151";
      Revision151->IsMarketingValue = false;

      default_field Revision152 = 1'h0;
      Revision152->name = "Revision152";
      Revision152->ValueDescription = "HQM Revision ID";
      Revision152->Values = "revision_id,Revision152";
      Revision152->IsMarketingValue = false;

      default_field Revision153 = 1'h0;
      Revision153->name = "Revision153";
      Revision153->ValueDescription = "HQM Revision ID";
      Revision153->Values = "revision_id,Revision153";
      Revision153->IsMarketingValue = false;

      default_field Revision154 = 1'h0;
      Revision154->name = "Revision154";
      Revision154->ValueDescription = "HQM Revision ID";
      Revision154->Values = "revision_id,Revision154";
      Revision154->IsMarketingValue = false;

      default_field Revision155 = 1'h0;
      Revision155->name = "Revision155";
      Revision155->ValueDescription = "HQM Revision ID";
      Revision155->Values = "revision_id,Revision155";
      Revision155->IsMarketingValue = false;

      default_field Revision156 = 1'h0;
      Revision156->name = "Revision156";
      Revision156->ValueDescription = "HQM Revision ID";
      Revision156->Values = "revision_id,Revision156";
      Revision156->IsMarketingValue = false;

      default_field Revision157 = 1'h0;
      Revision157->name = "Revision157";
      Revision157->ValueDescription = "HQM Revision ID";
      Revision157->Values = "revision_id,Revision157";
      Revision157->IsMarketingValue = false;

      default_field Revision158 = 1'h0;
      Revision158->name = "Revision158";
      Revision158->ValueDescription = "HQM Revision ID";
      Revision158->Values = "revision_id,Revision158";
      Revision158->IsMarketingValue = false;

      default_field Revision159 = 1'h0;
      Revision159->name = "Revision159";
      Revision159->ValueDescription = "HQM Revision ID";
      Revision159->Values = "revision_id,Revision159";
      Revision159->IsMarketingValue = false;

      default_field Revision160 = 1'h0;
      Revision160->name = "Revision160";
      Revision160->ValueDescription = "HQM Revision ID";
      Revision160->Values = "revision_id,Revision160";
      Revision160->IsMarketingValue = false;

      default_field Revision161 = 1'h0;
      Revision161->name = "Revision161";
      Revision161->ValueDescription = "HQM Revision ID";
      Revision161->Values = "revision_id,Revision161";
      Revision161->IsMarketingValue = false;

      default_field Revision162 = 1'h0;
      Revision162->name = "Revision162";
      Revision162->ValueDescription = "HQM Revision ID";
      Revision162->Values = "revision_id,Revision162";
      Revision162->IsMarketingValue = false;

      default_field Revision163 = 1'h0;
      Revision163->name = "Revision163";
      Revision163->ValueDescription = "HQM Revision ID";
      Revision163->Values = "revision_id,Revision163";
      Revision163->IsMarketingValue = false;

      default_field Revision164 = 1'h0;
      Revision164->name = "Revision164";
      Revision164->ValueDescription = "HQM Revision ID";
      Revision164->Values = "revision_id,Revision164";
      Revision164->IsMarketingValue = false;

      default_field Revision165 = 1'h0;
      Revision165->name = "Revision165";
      Revision165->ValueDescription = "HQM Revision ID";
      Revision165->Values = "revision_id,Revision165";
      Revision165->IsMarketingValue = false;

      default_field Revision166 = 1'h0;
      Revision166->name = "Revision166";
      Revision166->ValueDescription = "HQM Revision ID";
      Revision166->Values = "revision_id,Revision166";
      Revision166->IsMarketingValue = false;

      default_field Revision167 = 1'h0;
      Revision167->name = "Revision167";
      Revision167->ValueDescription = "HQM Revision ID";
      Revision167->Values = "revision_id,Revision167";
      Revision167->IsMarketingValue = false;

      default_field Revision168 = 1'h0;
      Revision168->name = "Revision168";
      Revision168->ValueDescription = "HQM Revision ID";
      Revision168->Values = "revision_id,Revision168";
      Revision168->IsMarketingValue = false;

      default_field Revision169 = 1'h0;
      Revision169->name = "Revision169";
      Revision169->ValueDescription = "HQM Revision ID";
      Revision169->Values = "revision_id,Revision169";
      Revision169->IsMarketingValue = false;

      default_field Revision170 = 1'h0;
      Revision170->name = "Revision170";
      Revision170->ValueDescription = "HQM Revision ID";
      Revision170->Values = "revision_id,Revision170";
      Revision170->IsMarketingValue = false;

      default_field Revision171 = 1'h0;
      Revision171->name = "Revision171";
      Revision171->ValueDescription = "HQM Revision ID";
      Revision171->Values = "revision_id,Revision171";
      Revision171->IsMarketingValue = false;

      default_field Revision172 = 1'h0;
      Revision172->name = "Revision172";
      Revision172->ValueDescription = "HQM Revision ID";
      Revision172->Values = "revision_id,Revision172";
      Revision172->IsMarketingValue = false;

      default_field Revision173 = 1'h0;
      Revision173->name = "Revision173";
      Revision173->ValueDescription = "HQM Revision ID";
      Revision173->Values = "revision_id,Revision173";
      Revision173->IsMarketingValue = false;

      default_field Revision174 = 1'h0;
      Revision174->name = "Revision174";
      Revision174->ValueDescription = "HQM Revision ID";
      Revision174->Values = "revision_id,Revision174";
      Revision174->IsMarketingValue = false;

      default_field Revision175 = 1'h0;
      Revision175->name = "Revision175";
      Revision175->ValueDescription = "HQM Revision ID";
      Revision175->Values = "revision_id,Revision175";
      Revision175->IsMarketingValue = false;

      default_field Revision176 = 1'h0;
      Revision176->name = "Revision176";
      Revision176->ValueDescription = "HQM Revision ID";
      Revision176->Values = "revision_id,Revision176";
      Revision176->IsMarketingValue = false;

      default_field Revision177 = 1'h0;
      Revision177->name = "Revision177";
      Revision177->ValueDescription = "HQM Revision ID";
      Revision177->Values = "revision_id,Revision177";
      Revision177->IsMarketingValue = false;

      default_field Revision178 = 1'h0;
      Revision178->name = "Revision178";
      Revision178->ValueDescription = "HQM Revision ID";
      Revision178->Values = "revision_id,Revision178";
      Revision178->IsMarketingValue = false;

      default_field Revision179 = 1'h0;
      Revision179->name = "Revision179";
      Revision179->ValueDescription = "HQM Revision ID";
      Revision179->Values = "revision_id,Revision179";
      Revision179->IsMarketingValue = false;

      default_field Revision180 = 1'h0;
      Revision180->name = "Revision180";
      Revision180->ValueDescription = "HQM Revision ID";
      Revision180->Values = "revision_id,Revision180";
      Revision180->IsMarketingValue = false;

      default_field Revision181 = 1'h0;
      Revision181->name = "Revision181";
      Revision181->ValueDescription = "HQM Revision ID";
      Revision181->Values = "revision_id,Revision181";
      Revision181->IsMarketingValue = false;

      default_field Revision182 = 1'h0;
      Revision182->name = "Revision182";
      Revision182->ValueDescription = "HQM Revision ID";
      Revision182->Values = "revision_id,Revision182";
      Revision182->IsMarketingValue = false;

      default_field Revision183 = 1'h0;
      Revision183->name = "Revision183";
      Revision183->ValueDescription = "HQM Revision ID";
      Revision183->Values = "revision_id,Revision183";
      Revision183->IsMarketingValue = false;

      default_field Revision184 = 1'h0;
      Revision184->name = "Revision184";
      Revision184->ValueDescription = "HQM Revision ID";
      Revision184->Values = "revision_id,Revision184";
      Revision184->IsMarketingValue = false;

      default_field Revision185 = 1'h0;
      Revision185->name = "Revision185";
      Revision185->ValueDescription = "HQM Revision ID";
      Revision185->Values = "revision_id,Revision185";
      Revision185->IsMarketingValue = false;

      default_field Revision186 = 1'h0;
      Revision186->name = "Revision186";
      Revision186->ValueDescription = "HQM Revision ID";
      Revision186->Values = "revision_id,Revision186";
      Revision186->IsMarketingValue = false;

      default_field Revision187 = 1'h0;
      Revision187->name = "Revision187";
      Revision187->ValueDescription = "HQM Revision ID";
      Revision187->Values = "revision_id,Revision187";
      Revision187->IsMarketingValue = false;

      default_field Revision188 = 1'h0;
      Revision188->name = "Revision188";
      Revision188->ValueDescription = "HQM Revision ID";
      Revision188->Values = "revision_id,Revision188";
      Revision188->IsMarketingValue = false;

      default_field Revision189 = 1'h0;
      Revision189->name = "Revision189";
      Revision189->ValueDescription = "HQM Revision ID";
      Revision189->Values = "revision_id,Revision189";
      Revision189->IsMarketingValue = false;

      default_field Revision190 = 1'h0;
      Revision190->name = "Revision190";
      Revision190->ValueDescription = "HQM Revision ID";
      Revision190->Values = "revision_id,Revision190";
      Revision190->IsMarketingValue = false;

      default_field Revision191 = 1'h0;
      Revision191->name = "Revision191";
      Revision191->ValueDescription = "HQM Revision ID";
      Revision191->Values = "revision_id,Revision191";
      Revision191->IsMarketingValue = false;

      default_field Revision192 = 1'h0;
      Revision192->name = "Revision192";
      Revision192->ValueDescription = "HQM Revision ID";
      Revision192->Values = "revision_id,Revision192";
      Revision192->IsMarketingValue = false;

      default_field Revision193 = 1'h0;
      Revision193->name = "Revision193";
      Revision193->ValueDescription = "HQM Revision ID";
      Revision193->Values = "revision_id,Revision193";
      Revision193->IsMarketingValue = false;

      default_field Revision194 = 1'h0;
      Revision194->name = "Revision194";
      Revision194->ValueDescription = "HQM Revision ID";
      Revision194->Values = "revision_id,Revision194";
      Revision194->IsMarketingValue = false;

      default_field Revision195 = 1'h0;
      Revision195->name = "Revision195";
      Revision195->ValueDescription = "HQM Revision ID";
      Revision195->Values = "revision_id,Revision195";
      Revision195->IsMarketingValue = false;

      default_field Revision196 = 1'h0;
      Revision196->name = "Revision196";
      Revision196->ValueDescription = "HQM Revision ID";
      Revision196->Values = "revision_id,Revision196";
      Revision196->IsMarketingValue = false;

      default_field Revision197 = 1'h0;
      Revision197->name = "Revision197";
      Revision197->ValueDescription = "HQM Revision ID";
      Revision197->Values = "revision_id,Revision197";
      Revision197->IsMarketingValue = false;

      default_field Revision198 = 1'h0;
      Revision198->name = "Revision198";
      Revision198->ValueDescription = "HQM Revision ID";
      Revision198->Values = "revision_id,Revision198";
      Revision198->IsMarketingValue = false;

      default_field Revision199 = 1'h0;
      Revision199->name = "Revision199";
      Revision199->ValueDescription = "HQM Revision ID";
      Revision199->Values = "revision_id,Revision199";
      Revision199->IsMarketingValue = false;

      default_field Revision200 = 1'h0;
      Revision200->name = "Revision200";
      Revision200->ValueDescription = "HQM Revision ID";
      Revision200->Values = "revision_id,Revision200";
      Revision200->IsMarketingValue = false;

      default_field Revision201 = 1'h0;
      Revision201->name = "Revision201";
      Revision201->ValueDescription = "HQM Revision ID";
      Revision201->Values = "revision_id,Revision201";
      Revision201->IsMarketingValue = false;

      default_field Revision202 = 1'h0;
      Revision202->name = "Revision202";
      Revision202->ValueDescription = "HQM Revision ID";
      Revision202->Values = "revision_id,Revision202";
      Revision202->IsMarketingValue = false;

      default_field Revision203 = 1'h0;
      Revision203->name = "Revision203";
      Revision203->ValueDescription = "HQM Revision ID";
      Revision203->Values = "revision_id,Revision203";
      Revision203->IsMarketingValue = false;

      default_field Revision204 = 1'h0;
      Revision204->name = "Revision204";
      Revision204->ValueDescription = "HQM Revision ID";
      Revision204->Values = "revision_id,Revision204";
      Revision204->IsMarketingValue = false;

      default_field Revision205 = 1'h0;
      Revision205->name = "Revision205";
      Revision205->ValueDescription = "HQM Revision ID";
      Revision205->Values = "revision_id,Revision205";
      Revision205->IsMarketingValue = false;

      default_field Revision206 = 1'h0;
      Revision206->name = "Revision206";
      Revision206->ValueDescription = "HQM Revision ID";
      Revision206->Values = "revision_id,Revision206";
      Revision206->IsMarketingValue = false;

      default_field Revision207 = 1'h0;
      Revision207->name = "Revision207";
      Revision207->ValueDescription = "HQM Revision ID";
      Revision207->Values = "revision_id,Revision207";
      Revision207->IsMarketingValue = false;

      default_field Revision208 = 1'h0;
      Revision208->name = "Revision208";
      Revision208->ValueDescription = "HQM Revision ID";
      Revision208->Values = "revision_id,Revision208";
      Revision208->IsMarketingValue = false;

      default_field Revision209 = 1'h0;
      Revision209->name = "Revision209";
      Revision209->ValueDescription = "HQM Revision ID";
      Revision209->Values = "revision_id,Revision209";
      Revision209->IsMarketingValue = false;

      default_field Revision210 = 1'h0;
      Revision210->name = "Revision210";
      Revision210->ValueDescription = "HQM Revision ID";
      Revision210->Values = "revision_id,Revision210";
      Revision210->IsMarketingValue = false;

      default_field Revision211 = 1'h0;
      Revision211->name = "Revision211";
      Revision211->ValueDescription = "HQM Revision ID";
      Revision211->Values = "revision_id,Revision211";
      Revision211->IsMarketingValue = false;

      default_field Revision212 = 1'h0;
      Revision212->name = "Revision212";
      Revision212->ValueDescription = "HQM Revision ID";
      Revision212->Values = "revision_id,Revision212";
      Revision212->IsMarketingValue = false;

      default_field Revision213 = 1'h0;
      Revision213->name = "Revision213";
      Revision213->ValueDescription = "HQM Revision ID";
      Revision213->Values = "revision_id,Revision213";
      Revision213->IsMarketingValue = false;

      default_field Revision214 = 1'h0;
      Revision214->name = "Revision214";
      Revision214->ValueDescription = "HQM Revision ID";
      Revision214->Values = "revision_id,Revision214";
      Revision214->IsMarketingValue = false;

      default_field Revision215 = 1'h0;
      Revision215->name = "Revision215";
      Revision215->ValueDescription = "HQM Revision ID";
      Revision215->Values = "revision_id,Revision215";
      Revision215->IsMarketingValue = false;

      default_field Revision216 = 1'h0;
      Revision216->name = "Revision216";
      Revision216->ValueDescription = "HQM Revision ID";
      Revision216->Values = "revision_id,Revision216";
      Revision216->IsMarketingValue = false;

      default_field Revision217 = 1'h0;
      Revision217->name = "Revision217";
      Revision217->ValueDescription = "HQM Revision ID";
      Revision217->Values = "revision_id,Revision217";
      Revision217->IsMarketingValue = false;

      default_field Revision218 = 1'h0;
      Revision218->name = "Revision218";
      Revision218->ValueDescription = "HQM Revision ID";
      Revision218->Values = "revision_id,Revision218";
      Revision218->IsMarketingValue = false;

      default_field Revision219 = 1'h0;
      Revision219->name = "Revision219";
      Revision219->ValueDescription = "HQM Revision ID";
      Revision219->Values = "revision_id,Revision219";
      Revision219->IsMarketingValue = false;

      default_field Revision220 = 1'h0;
      Revision220->name = "Revision220";
      Revision220->ValueDescription = "HQM Revision ID";
      Revision220->Values = "revision_id,Revision220";
      Revision220->IsMarketingValue = false;

      default_field Revision221 = 1'h0;
      Revision221->name = "Revision221";
      Revision221->ValueDescription = "HQM Revision ID";
      Revision221->Values = "revision_id,Revision221";
      Revision221->IsMarketingValue = false;

      default_field Revision222 = 1'h0;
      Revision222->name = "Revision222";
      Revision222->ValueDescription = "HQM Revision ID";
      Revision222->Values = "revision_id,Revision222";
      Revision222->IsMarketingValue = false;

      default_field Revision223 = 1'h0;
      Revision223->name = "Revision223";
      Revision223->ValueDescription = "HQM Revision ID";
      Revision223->Values = "revision_id,Revision223";
      Revision223->IsMarketingValue = false;

      default_field Revision224 = 1'h0;
      Revision224->name = "Revision224";
      Revision224->ValueDescription = "HQM Revision ID";
      Revision224->Values = "revision_id,Revision224";
      Revision224->IsMarketingValue = false;

      default_field Revision225 = 1'h0;
      Revision225->name = "Revision225";
      Revision225->ValueDescription = "HQM Revision ID";
      Revision225->Values = "revision_id,Revision225";
      Revision225->IsMarketingValue = false;

      default_field Revision226 = 1'h0;
      Revision226->name = "Revision226";
      Revision226->ValueDescription = "HQM Revision ID";
      Revision226->Values = "revision_id,Revision226";
      Revision226->IsMarketingValue = false;

      default_field Revision227 = 1'h0;
      Revision227->name = "Revision227";
      Revision227->ValueDescription = "HQM Revision ID";
      Revision227->Values = "revision_id,Revision227";
      Revision227->IsMarketingValue = false;

      default_field Revision228 = 1'h0;
      Revision228->name = "Revision228";
      Revision228->ValueDescription = "HQM Revision ID";
      Revision228->Values = "revision_id,Revision228";
      Revision228->IsMarketingValue = false;

      default_field Revision229 = 1'h0;
      Revision229->name = "Revision229";
      Revision229->ValueDescription = "HQM Revision ID";
      Revision229->Values = "revision_id,Revision229";
      Revision229->IsMarketingValue = false;

      default_field Revision230 = 1'h0;
      Revision230->name = "Revision230";
      Revision230->ValueDescription = "HQM Revision ID";
      Revision230->Values = "revision_id,Revision230";
      Revision230->IsMarketingValue = false;

      default_field Revision231 = 1'h0;
      Revision231->name = "Revision231";
      Revision231->ValueDescription = "HQM Revision ID";
      Revision231->Values = "revision_id,Revision231";
      Revision231->IsMarketingValue = false;

      default_field Revision232 = 1'h0;
      Revision232->name = "Revision232";
      Revision232->ValueDescription = "HQM Revision ID";
      Revision232->Values = "revision_id,Revision232";
      Revision232->IsMarketingValue = false;

      default_field Revision233 = 1'h0;
      Revision233->name = "Revision233";
      Revision233->ValueDescription = "HQM Revision ID";
      Revision233->Values = "revision_id,Revision233";
      Revision233->IsMarketingValue = false;

      default_field Revision234 = 1'h0;
      Revision234->name = "Revision234";
      Revision234->ValueDescription = "HQM Revision ID";
      Revision234->Values = "revision_id,Revision234";
      Revision234->IsMarketingValue = false;

      default_field Revision235 = 1'h0;
      Revision235->name = "Revision235";
      Revision235->ValueDescription = "HQM Revision ID";
      Revision235->Values = "revision_id,Revision235";
      Revision235->IsMarketingValue = false;

      default_field Revision236 = 1'h0;
      Revision236->name = "Revision236";
      Revision236->ValueDescription = "HQM Revision ID";
      Revision236->Values = "revision_id,Revision236";
      Revision236->IsMarketingValue = false;

      default_field Revision237 = 1'h0;
      Revision237->name = "Revision237";
      Revision237->ValueDescription = "HQM Revision ID";
      Revision237->Values = "revision_id,Revision237";
      Revision237->IsMarketingValue = false;

      default_field Revision238 = 1'h0;
      Revision238->name = "Revision238";
      Revision238->ValueDescription = "HQM Revision ID";
      Revision238->Values = "revision_id,Revision238";
      Revision238->IsMarketingValue = false;

      default_field Revision239 = 1'h0;
      Revision239->name = "Revision239";
      Revision239->ValueDescription = "HQM Revision ID";
      Revision239->Values = "revision_id,Revision239";
      Revision239->IsMarketingValue = false;

      default_field Revision240 = 1'h0;
      Revision240->name = "Revision240";
      Revision240->ValueDescription = "HQM Revision ID";
      Revision240->Values = "revision_id,Revision240";
      Revision240->IsMarketingValue = false;

      default_field Revision241 = 1'h0;
      Revision241->name = "Revision241";
      Revision241->ValueDescription = "HQM Revision ID";
      Revision241->Values = "revision_id,Revision241";
      Revision241->IsMarketingValue = false;

      default_field Revision242 = 1'h0;
      Revision242->name = "Revision242";
      Revision242->ValueDescription = "HQM Revision ID";
      Revision242->Values = "revision_id,Revision242";
      Revision242->IsMarketingValue = false;

      default_field Revision243 = 1'h0;
      Revision243->name = "Revision243";
      Revision243->ValueDescription = "HQM Revision ID";
      Revision243->Values = "revision_id,Revision243";
      Revision243->IsMarketingValue = false;

      default_field Revision244 = 1'h0;
      Revision244->name = "Revision244";
      Revision244->ValueDescription = "HQM Revision ID";
      Revision244->Values = "revision_id,Revision244";
      Revision244->IsMarketingValue = false;

      default_field Revision245 = 1'h0;
      Revision245->name = "Revision245";
      Revision245->ValueDescription = "HQM Revision ID";
      Revision245->Values = "revision_id,Revision245";
      Revision245->IsMarketingValue = false;

      default_field Revision246 = 1'h0;
      Revision246->name = "Revision246";
      Revision246->ValueDescription = "HQM Revision ID";
      Revision246->Values = "revision_id,Revision246";
      Revision246->IsMarketingValue = false;

      default_field Revision247 = 1'h0;
      Revision247->name = "Revision247";
      Revision247->ValueDescription = "HQM Revision ID";
      Revision247->Values = "revision_id,Revision247";
      Revision247->IsMarketingValue = false;

      default_field Revision248 = 1'h0;
      Revision248->name = "Revision248";
      Revision248->ValueDescription = "HQM Revision ID";
      Revision248->Values = "revision_id,Revision248";
      Revision248->IsMarketingValue = false;

      default_field Revision249 = 1'h0;
      Revision249->name = "Revision249";
      Revision249->ValueDescription = "HQM Revision ID";
      Revision249->Values = "revision_id,Revision249";
      Revision249->IsMarketingValue = false;

      default_field Revision250 = 1'h0;
      Revision250->name = "Revision250";
      Revision250->ValueDescription = "HQM Revision ID";
      Revision250->Values = "revision_id,Revision250";
      Revision250->IsMarketingValue = false;

      default_field Revision251 = 1'h0;
      Revision251->name = "Revision251";
      Revision251->ValueDescription = "HQM Revision ID";
      Revision251->Values = "revision_id,Revision251";
      Revision251->IsMarketingValue = false;

      default_field Revision252 = 1'h0;
      Revision252->name = "Revision252";
      Revision252->ValueDescription = "HQM Revision ID";
      Revision252->Values = "revision_id,Revision252";
      Revision252->IsMarketingValue = false;

      default_field Revision253 = 1'h0;
      Revision253->name = "Revision253";
      Revision253->ValueDescription = "HQM Revision ID";
      Revision253->Values = "revision_id,Revision253";
      Revision253->IsMarketingValue = false;

      default_field Revision254 = 1'h0;
      Revision254->name = "Revision254";
      Revision254->ValueDescription = "HQM Revision ID";
      Revision254->Values = "revision_id,Revision254";
      Revision254->IsMarketingValue = false;

      default_field Revision255 = 1'h0;
      Revision255->name = "Revision255";
      Revision255->ValueDescription = "HQM Revision ID";
      Revision255->Values = "revision_id,Revision255";
      Revision255->IsMarketingValue = false;
    };

    HQM_Revision HQM_Revision;
  };

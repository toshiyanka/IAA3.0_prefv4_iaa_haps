 reg cfg_reset_vf_start_r {
  name = "cfg_reset_vf_start";
  desc = "cfg_reset_vf_start";
  field { hw = rw; sw = rw; fieldwidth = 1; desc = "";  } vf_reset_start[0:0] = 1'h0;
  field { hw = rw; sw = rw; fieldwidth = 4; desc = "";  } vf_reset_type[07:04] = 4'h0;
  field { hw = rw; sw = rw; fieldwidth = 24; desc = "";  } vf_reset_id[31:08] = 24'h0;
 };

 reg cfg_reset_reserved_01_r {  name = "reserved";
  desc = "reserved";
  field { hw = rw; sw = rw; fieldwidth = 32; desc = "reserved";  } reserved[31:0] = 32'h0; };

 reg cfg_reset_reserved_02_r {  name = "reserved";
  desc = "reserved";
  field { hw = rw; sw = rw; fieldwidth = 32; desc = "reserved";  } reserved[31:0] = 32'h0; };

 reg cfg_reset_reserved_03_r {   name = "reserved";
  desc = "reserved";
  field { hw = rw; sw = rw; fieldwidth = 32; desc = "reserved";  } reserved[31:0] = 32'h0; };


regfile hqm_AW_cfg_ring_rf {

  cfg_reset_vf_start_r    cfg_reset_vf_start    ; 
  cfg_reset_reserved_01_r cfg_reset_reserved_01 ;
  cfg_reset_reserved_02_r cfg_reset_reserved_02 ;
  cfg_reset_reserved_03_r cfg_reset_reserved_03 ;

};
